simulator lang=spectre insensitive=yes
model modn bsim4  {
    1:  type=n
+ drout=0.5  saref=1e-05  pbsws=0.32
+ llc=0.0  pdiblcb=0.0  xw=0.0
+ cdsc=0.0  clc=1e-07  minv=-0.34
+ pbswgd=0.952  cdscb=0.0  toxe=3.981e-09
+ cjd=1e-10  cjswgs=3.82e-10  binunit=2.0
+ jtsswgs=1.09e-09  cigsd=3.925e-20  wlodku0=1.0
+ tpbsw=0.000894  rsw=90.88  njd=1.0
+ w0=0.0  pdiblc1=0.0  dwb=0.0
+ igbmod=0.0  dmdg=0.0  delta=0.005
+ wlodvth=1.0  etab=-0.308  permod=1.0
+ tnjtsswg=1.08  dlcig=2.5e-09  rshg=8.23
+ xgl=-3.1e-08  acde=0.4  capmod=2.0
+ noia=1.25e+42  tcjswg=0.00088  cgdo=1e-10
+ rbdb=50.0  cigbinv=0.006  jswgs=6.9e-13
+ wlod=5e-07  xrcrg2=1.0  jsd=2.85e-07
+ prt=0.0  minr=0.001  dmci=3.15e-07
+ ww=0.0  cigbacc=0.2809  wlc=0.0
+ dwj=0.0  dvt1w=0.0  mjswgd=0.541
+ aigbacc=0.01213  beta0=17.8  a1=0.0
+ alpha0=1.454e-07  dvt0=0.09708  lln=1.0
+ aigc=0.01  trnqsmod=0.0  cjs=1e-10
+ lodeta0=2.0  cf=1.0  ijthsfwd=0.01
+ ckappad=0.6  rbsb=50.0  xtsswgd=0.2886
+ ud=0.0  epsrox=3.9  rbpd=50.0
+ tempmod=0.0  alpha1=2.295  pbd=0.6882682
+ tvoff=0.0015  xtid=3.0  acnqsmod=0.0
+ nigbacc=4.05  rgatemod=0.0  cgbo=0.0
+ rsh=7.28  jtsswgd=1.09e-09  ngate=9e+19
+ tcjsw=0.000809  poxedge=1.0  xtsswgs=0.2886
+ mjswd=0.202  xrcrg1=12.0  pditsl=0.0
+ noff=1.973  lpeb=2.178e-08  ckappas=0.6
+ noib=7e+23  dmcgt=0.0  dsub=0.633
+ ll=0.0  cgso=1e-10  vtsswgs=10.0
+ jss=2.85e-07  ntox=1.0  dvtp1=0.0
+ mobmod=0.0  njs=1.0  cigc=1.515e-05
+ cjswd=1.185e-10  voffcv=-0.0904  mjsws=0.202
+ nigbinv=1.0  xl=-1.5e-08  ef=0.904
+ wl=0.0  rbodymod=0.0  lwc=0.0
+ wr=1.0  jswd=6.9e-13  pbs=0.6882682
+ dvt2w=0.0  wln=1.0  cdscd=0.0
+ ijthdrev=0.01  dvt0w=0.0  jsws=6.9e-13
+ nigc=1.0  b1=0.0  lint=2.595e-08
+ rbpb=50.0  noic=60800000.0  egidl=0.2624
+ wwc=0.0  dlc=2.595e-08  pbswgs=0.952
+ vtsswgd=10.0  fprout=0.0  lwn=1.0
+ lwl=0.0  ku0we=0.0  rgeomod=1.0
+ rbps=50.0  stk2=2.5e-09  k3=-3.7
+ dwg=0.0  bigc=0.00144  llodku0=1.0
+ bigbinv=0.03  tku0=0.03  xtis=3.0
+ steta0=-1.1e-10  wec=0.0  pscbe2=1e-20
+ pigcd=2.171  dvt1=0.3053  em=30000000.0
+ ijthdfwd=0.01  lodk2=1.0  xj=1.6e-07
+ ijthsrev=0.01  cle=0.6  aigbinv=0.35
+ njtsswg=11.6  tnom=25.0  ndep=5.8e+17
+ mjs=0.359  cgidl=0.25  eigbinv=1.1
+ xjbvd=1.0  phin=0.0  prwg=0.0
+ nsd=1e+20  toxref=3e-09  wwlc=0.0
+ mjswgs=0.541  lw=0.0  bigbacc=0.006537
+ agidl=2.593e-09  wpemod=1.0  dwc=0.0
+ cgdl=1e-10  tpbswg=0.00133  wint=1.02e-08
+ jswgd=6.9e-13  xgw=0.0  a2=0.995
+ dvtp0=1.46e-06  lpe0=9.921e-09  kt1l=0.0
+ k1=0.448  gbmin=1e-12  dmcg=2.05e-07
+ paramchk=1.0  kvsat=0.4  tpb=0.00149
+ voffl=-1.22e-09  xpart=1.0  pbswd=0.32
+ pscbe1=450000000.0  wwl=0.0  cjswgd=3.82e-10
+ ngcon=1.0  mjd=0.359  dvt2=-0.6939
+ llodvth=1.0  pvag=0.6279  k2we=0.0038
+ diomod=1.0  sbref=1e-05  rdsw=200.0
+ tcj=0.000905  rdsmod=1.0  aigsd=0.008379
+ bvs=11.25  dtox=5.958e-10  bgidl=1850800000.0
+ prwb=0.0  wwn=1.0  cgsl=1e-10
+ moin=5.346  bvd=11.25  version=4.5
+ pditsd=0.0  scref=1e-06  bigsd=0.0002699
+ rdw=90.88  igcmod=0.0  b0=0.0
+ lwlc=0.0  fnoimod=1.0  toxm=3.981e-09
+ pdits=0.0  web=0.0  xjbvs=1.0
+ k3b=1.2  cjsws=1.185e-10  at=117832.01302679551
+ lat=0.00033012614948301736  wat=-8.394395758982792e-06  pat=-1.345393144314971e-13
+ ua=-1.1120551629009633e-09  lua=5.124187457468373e-18  wua=-9.4242054583481e-19
+ pua=1.1288651552566356e-26  ub=2.3265130131232163e-18  lub=-4.282339003646499e-27
+ wub=9.939722366429929e-28  pub=-9.89704342830647e-36  kvth0=2.1999999937700907e-09
+ lkvth0=-9.99999999999955e-09  wkvth0=2.2e-06  pkvth0=-5.0000000000004154e-14
+ pdiblc2=0.0009754696792055897  lpdiblc2=-9.392793198313572e-12  wpdiblc2=-3.52862070662942e-14
+ ppdiblc2=-6.121720906972646e-21  nfactor=0.9497263933886516  lnfactor=-1.1347592247075805e-10
+ wnfactor=-6.476063726757498e-10  pnfactor=-9.698076200688168e-19  width=0.00091006
+ lwidth=-0.0  wwidth=-9.0273009e-09  pwidth=0.0
+ cit=0.0008281621613595506  lcit=7.563397030336266e-12  wcit=-2.9823353629252735e-13
+ pcit=2.6727857282576903e-21  length=3.0000000000000008e-05  llength=-2.0000000000000008e-10
+ wlength=-2.2522061369436854e-26  plength=2.2522061369436863e-31  u0=0.030523928894704774
+ lu0=4.1545284556203094e-11  wu0=-5.5484192389102875e-12  pu0=1.0390290138100353e-19
+ ags=0.5008130620969888  lags=-1.8624235543826251e-09  wags=5.3014477201990196e-11
+ pags=3.1990504659408392e-18  ute=-1.811476349295795  lute=-4.289372499832794e-09
+ wute=-3.439952506789508e-10  pute=2.2499233458529013e-18  ku0=-3.1999999990798564e-08
+ lku0=1.9999999999999983e-07  wku0=6.999999999999999e-07  pku0=-4.9999999999998525e-14
+ voff=-0.1305488871465572  lvoff=-2.2401163237620207e-11  wvoff=6.490617843561544e-12
+ pvoff=-1.230902217689511e-19  eta0=0.2277358920531289  leta0=-5.152488839269334e-10
+ weta0=-1.166017026332833e-10  peta0=-1.0044992126643205e-18  kt1=-0.24612438952578905
+ lkt1=1.7141048094950467e-10  wkt1=-3.692302058594486e-11  pkt1=4.671610764807931e-19
+ kt2=-0.05519139005583587  lkt2=-3.012927552185798e-12  wkt2=-2.647565361539746e-13
+ pkt2=-6.520525272010259e-20  kvth0we=0.003492662267580879  lkvth0we=1.024354168937805e-12
+ wkvth0we=1.3427656283189606e-14  pkvth0we=-3.752164427049036e-21  vth0=0.43952844274919833
+ lvth0=3.15712946841681e-11  wvth0=-1.9205918710379728e-11  pvth0=4.547993250908951e-19
+ a0=1.072430523366358  la0=-6.087324957005845e-10  wa0=-7.795732082086041e-11
+ pa0=-2.2539431284040553e-18  keta=-0.05139791384277191  lketa=4.5874160555060215e-10
+ wketa=-2.0932202997724472e-11  pketa=3.550163273867193e-19  uc1=-8.072156970848595e-11
+ luc1=4.33898195786382e-19  wuc1=-7.136474138586866e-20  puc1=1.623846261630773e-27
+ ub1=-4.429906354722726e-18  lub1=6.419825331712415e-28  wub1=-2.205318973037961e-28
+ pub1=1.1220517275968066e-35  ua1=2.341850863403034e-09  lua1=-6.292263453935463e-18
+ wua1=-3.1492322742867683e-19  pua1=-5.8916570403832514e-27  pclm=0.7188316773402809
+ lpclm=7.647183449454443e-10  wpclm=7.799634698348743e-11  ppclm=1.4896001977151593e-18
+ k2=0.044341741344662455  lk2=5.227372144207317e-12  wk2=-2.4387774943561806e-12
+ pk2=-6.493200662580965e-20  vsat=73329.36222754557  lvsat=-7.354414057491704e-06
+ wvsat=4.9433737678302534e-06  pvsat=1.2651997115546555e-14  uc=1.9164814850975925e-10
+ luc=4.331034014439737e-19  wuc=1.7662210386485581e-19  puc=1.4387485152751236e-27
+ lmin=1e-005  lmax=2e-05  wmin=1.003e-005
+ wmax=90.003e-05

    2:  type=n
+ drout=0.5  saref=1e-05  pbsws=0.32
+ llc=0.0  pdiblcb=0.0  xw=0.0
+ cdsc=0.0  clc=1e-07  minv=-0.34
+ pbswgd=0.952  cdscb=0.0  toxe=3.981e-09
+ cjd=1e-10  cjswgs=3.82e-10  binunit=2.0
+ jtsswgs=1.09e-09  cigsd=3.925e-20  wlodku0=1.0
+ tpbsw=0.000894  rsw=90.88  njd=1.0
+ w0=0.0  pdiblc1=0.0  dwb=0.0
+ igbmod=0.0  dmdg=0.0  delta=0.005
+ wlodvth=1.0  etab=-0.308  permod=1.0
+ tnjtsswg=1.08  dlcig=2.5e-09  rshg=8.23
+ xgl=-3.1e-08  acde=0.4  capmod=2.0
+ noia=1.25e+42  tcjswg=0.00088  cgdo=1e-10
+ rbdb=50.0  cigbinv=0.006  jswgs=6.9e-13
+ wlod=5e-07  xrcrg2=1.0  jsd=2.85e-07
+ prt=0.0  minr=0.001  dmci=3.15e-07
+ ww=0.0  cigbacc=0.2809  wlc=0.0
+ dwj=0.0  dvt1w=0.0  mjswgd=0.541
+ aigbacc=0.01213  beta0=17.8  a1=0.0
+ alpha0=1.454e-07  dvt0=0.09708  lln=1.0
+ aigc=0.01  trnqsmod=0.0  cjs=1e-10
+ lodeta0=2.0  cf=1.0  ijthsfwd=0.01
+ ckappad=0.6  rbsb=50.0  xtsswgd=0.2886
+ ud=0.0  epsrox=3.9  rbpd=50.0
+ tempmod=0.0  alpha1=2.295  pbd=0.6882682
+ xtid=3.0  acnqsmod=0.0  nigbacc=4.05
+ rgatemod=0.0  cgbo=0.0  rsh=7.28
+ jtsswgd=1.09e-09  ngate=9e+19  tcjsw=0.000809
+ poxedge=1.0  xtsswgs=0.2886  mjswd=0.202
+ xrcrg1=12.0  pditsl=0.0  noff=1.973
+ lpeb=2.178e-08  ckappas=0.6  noib=7e+23
+ dmcgt=0.0  dsub=0.633  ll=0.0
+ cgso=1e-10  vtsswgs=10.0  jss=2.85e-07
+ ntox=1.0  dvtp1=0.0  mobmod=0.0
+ njs=1.0  cigc=1.515e-05  cjswd=1.185e-10
+ voffcv=-0.0904  mjsws=0.202  nigbinv=1.0
+ xl=-1.5e-08  ef=0.904  wl=0.0
+ rbodymod=0.0  lwc=0.0  wr=1.0
+ jswd=6.9e-13  pbs=0.6882682  dvt2w=0.0
+ wln=1.0  cdscd=0.0  ijthdrev=0.01
+ dvt0w=0.0  jsws=6.9e-13  nigc=1.0
+ b1=0.0  lint=2.595e-08  rbpb=50.0
+ noic=60800000.0  egidl=0.2624  wwc=0.0
+ dlc=2.595e-08  pbswgs=0.952  vtsswgd=10.0
+ fprout=0.0  lwn=1.0  lwl=0.0
+ ku0we=0.0  rgeomod=1.0  rbps=50.0
+ stk2=2.5e-09  k3=-3.7  dwg=0.0
+ bigc=0.00144  llodku0=1.0  bigbinv=0.03
+ tku0=0.03  xtis=3.0  steta0=-1.1e-10
+ wec=0.0  pscbe2=1e-20  pigcd=2.171
+ dvt1=0.3053  em=30000000.0  ijthdfwd=0.01
+ lodk2=1.0  xj=1.6e-07  ijthsrev=0.01
+ cle=0.6  aigbinv=0.35  njtsswg=11.6
+ tnom=25.0  ndep=5.8e+17  mjs=0.359
+ cgidl=0.25  eigbinv=1.1  xjbvd=1.0
+ phin=0.0  prwg=0.0  nsd=1e+20
+ toxref=3e-09  wwlc=0.0  mjswgs=0.541
+ lw=0.0  bigbacc=0.006537  agidl=2.593e-09
+ wpemod=1.0  dwc=0.0  cgdl=1e-10
+ tpbswg=0.00133  wint=1.02e-08  jswgd=6.9e-13
+ xgw=0.0  a2=0.995  dvtp0=1.46e-06
+ lpe0=9.921e-09  kt1l=0.0  k1=0.448
+ gbmin=1e-12  dmcg=2.05e-07  paramchk=1.0
+ kvsat=0.4  tpb=0.00149  voffl=-1.22e-09
+ xpart=1.0  pbswd=0.32  pscbe1=450000000.0
+ wwl=0.0  cjswgd=3.82e-10  ngcon=1.0
+ mjd=0.359  dvt2=-0.6939  llodvth=1.0
+ pvag=0.6279  k2we=0.0038  diomod=1.0
+ sbref=1e-05  rdsw=200.0  tcj=0.000905
+ rdsmod=1.0  aigsd=0.008379  bvs=11.25
+ dtox=5.958e-10  bgidl=1850800000.0  prwb=0.0
+ wwn=1.0  cgsl=1e-10  moin=5.346
+ bvd=11.25  version=4.5  pditsd=0.0
+ scref=1e-06  bigsd=0.0002699  rdw=90.88
+ igcmod=0.0  b0=0.0  lwlc=0.0
+ fnoimod=1.0  toxm=3.981e-09  pdits=0.0
+ web=0.0  xjbvs=1.0  k3b=1.2
+ cjsws=1.185e-10  at=122780.92233033865  lat=-0.04915896688594853
+ wat=-1.1302226989991034e-05  pat=2.8943772995650936e-11  ua=-1.0308859927240584e-09
+ lua=-8.065675143115791e-16  wua=-7.618578328072963e-19  pua=-1.7943384787225697e-24
+ ub=2.258447165650377e-18  lub=6.763761357247444e-25  wub=8.424768335374454e-28
+ pub=1.5050569876271699e-33  kvth0=2.200000027692119e-09  lkvth0=-1.0000000000000022e-08
+ wkvth0=2.1999999999999997e-06  pkvth0=-4.999999999999966e-14  pdiblc2=0.0008291696642925103
+ lpdiblc2=1.4536073559324822e-09  wpdiblc2=-1.29049378877375e-13  ppdiblc2=9.315099972038357e-19
+ nfactor=0.9477397152510624  lnfactor=1.9753305453421756e-08  wnfactor=-6.701346567921066e-10
+ pnfactor=2.243130335434995e-16  width=0.00091006  lwidth=0.0
+ wwidth=-9.0273009e-09  pwidth=-0.0  cit=0.0009465180443312474
+ lcit=-1.1759954326866317e-09  wcit=-2.5089512195668003e-13  pcit=-4.707113576302157e-19
+ length=1.1200000000000001e-05  llength=-1.2e-11  wlength=-0.0
+ plength=-0.0  u0=0.03118183036403007  lu0=-6.537469408696761e-09
+ wu0=-4.178334517077401e-12  pu0=-1.3596944316947871e-17  tvoff=0.0015000000011010808
+ ltvoff=-1.1010808223141062e-17  wtvoff=-9.91005772507349e-16  ptvoff=9.910057725073492e-21
+ ags=0.47156251091665413  lags=2.9064308824896436e-07  wags=9.674641789188233e-11
+ pags=-4.341203564329805e-16  ute=-1.877555307025886  lute=6.56500204801077e-07
+ wute=-3.773654175800992e-10  pute=3.359515923573363e-16  ku0=-3.2000000003210985e-08
+ lku0=2e-07  wku0=7e-07  pku0=-5.0000000000000235e-14
+ voff=-0.13092333657620375  lvoff=3.722093133227646e-09  wvoff=4.50225617033324e-12
+ pvoff=1.9760526510514094e-17  eta0=0.21978025581020122  leta0=7.904111354535016e-08
+ weta0=-1.279607190456618e-10  peta0=1.1258566491112063e-16  kt1=-0.2434755318726358
+ lkt1=-2.6317166050582836e-08  wkt1=-3.8355678968595995e-11  pkt1=1.479374490299215e-17
+ kt2=-0.0552387291671559  lkt2=4.70378185648151e-10  wkt2=-3.5070773883843067e-13
+ pkt2=7.943067741244588e-19  kvth0we=0.003507996439698736  lkvth0we=-1.5231736700963498e-10
+ wkvth0we=1.489663417622327e-14  pkvth0we=-1.8441943357385676e-20  vth0=0.44005826683557997
+ lvth0=-5.2666695691318685e-09  wvth0=-1.7760568537667382e-11  pvth0=-1.3998702402032583e-17
+ a0=1.061253704532693  la0=1.1115945584095107e-07  wa0=-1.472661504096953e-10
+ pa0=6.908343527599451e-16  keta=-0.04426684438260118  lketa=-7.085195299615667e-08
+ wketa=-1.5651635180586923e-11  pketa=-5.245066184398879e-17  uc1=-7.367887160814441e-11
+ luc1=-6.999308280762896e-17  wuc1=-4.7849719516107426e-20  puc1=-2.3352637243598165e-25
+ ub1=-4.417700971405919e-18  lub1=-1.2141185063490696e-25  wub1=-9.528330431857982e-29
+ pub1=-1.241265412576195e-33  ua1=2.2441723858984264e-09  lua1=9.704925115921415e-16
+ wua1=-3.82605427691841e-19  pua1=6.7093034559125845e-25  pclm=0.7307071821441132
+ lpclm=-1.1799032969337981e-07  wpclm=9.487459681608464e-11  ppclm=-1.6729289812825703e-16
+ k2=0.04441523255496016  lk2=-7.296847308328636e-10  wk2=-3.3683264208341145e-12
+ pk2=9.230557258153534e-18  vsat=73189.23417600353  lvsat=0.0013939261013629072
+ wvsat=4.996308803845057e-06  pvsat=-5.166983630324807e-13  uc=1.9827874945007947e-10
+ luc=-6.587290600175829e-17  wuc=1.9221156257782366e-19  puc=-1.5445583861440353e-25
+ lmin=1.2e-006  lmax=1e-005  wmin=1.003e-005
+ wmax=90.003e-05

    3:  type=n
+ drout=0.5  saref=1e-05  pbsws=0.32
+ llc=0.0  pdiblcb=0.0  xw=0.0
+ cdsc=0.0  clc=1e-07  minv=-0.34
+ pbswgd=0.952  cdscb=0.0  toxe=3.981e-09
+ cjd=1e-10  cjswgs=3.82e-10  binunit=2.0
+ jtsswgs=1.09e-09  cigsd=3.925e-20  wlodku0=1.0
+ tpbsw=0.000894  rsw=90.88  njd=1.0
+ w0=0.0  pdiblc1=0.0  dwb=0.0
+ igbmod=0.0  dmdg=0.0  delta=0.005
+ wlodvth=1.0  etab=-0.308  permod=1.0
+ tnjtsswg=1.08  dlcig=2.5e-09  rshg=8.23
+ xgl=-3.1e-08  acde=0.4  capmod=2.0
+ noia=1.25e+42  tcjswg=0.00088  cgdo=1e-10
+ rbdb=50.0  cigbinv=0.006  jswgs=6.9e-13
+ wlod=5e-07  xrcrg2=1.0  jsd=2.85e-07
+ prt=0.0  minr=0.001  dmci=3.15e-07
+ ww=0.0  cigbacc=0.2809  wlc=0.0
+ dwj=0.0  dvt1w=0.0  mjswgd=0.541
+ aigbacc=0.01213  beta0=17.8  a1=0.0
+ alpha0=1.454e-07  dvt0=0.09708  lln=1.0
+ aigc=0.01  trnqsmod=0.0  cjs=1e-10
+ lodeta0=2.0  cf=1.0  ijthsfwd=0.01
+ ckappad=0.6  rbsb=50.0  xtsswgd=0.2886
+ ud=0.0  epsrox=3.9  rbpd=50.0
+ tempmod=0.0  alpha1=2.295  pbd=0.6882682
+ xtid=3.0  acnqsmod=0.0  nigbacc=4.05
+ rgatemod=0.0  cgbo=0.0  rsh=7.28
+ jtsswgd=1.09e-09  ngate=9e+19  tcjsw=0.000809
+ poxedge=1.0  xtsswgs=0.2886  mjswd=0.202
+ xrcrg1=12.0  pditsl=0.0  noff=1.973
+ lpeb=2.178e-08  ckappas=0.6  noib=7e+23
+ dmcgt=0.0  dsub=0.633  ll=0.0
+ cgso=1e-10  vtsswgs=10.0  jss=2.85e-07
+ ntox=1.0  dvtp1=0.0  mobmod=0.0
+ njs=1.0  cigc=1.515e-05  cjswd=1.185e-10
+ voffcv=-0.0904  mjsws=0.202  nigbinv=1.0
+ xl=-1.5e-08  ef=0.904  wl=0.0
+ rbodymod=0.0  lwc=0.0  wr=1.0
+ jswd=6.9e-13  pbs=0.6882682  dvt2w=0.0
+ wln=1.0  cdscd=0.0  ijthdrev=0.01
+ dvt0w=0.0  jsws=6.9e-13  nigc=1.0
+ b1=0.0  lint=2.595e-08  rbpb=50.0
+ noic=60800000.0  egidl=0.2624  wwc=0.0
+ dlc=2.595e-08  pbswgs=0.952  vtsswgd=10.0
+ fprout=0.0  lwn=1.0  lwl=0.0
+ ku0we=0.0  rgeomod=1.0  rbps=50.0
+ stk2=2.5e-09  k3=-3.7  dwg=0.0
+ bigc=0.00144  llodku0=1.0  bigbinv=0.03
+ tku0=0.03  xtis=3.0  steta0=-1.1e-10
+ wec=0.0  pscbe2=1e-20  pigcd=2.171
+ dvt1=0.3053  em=30000000.0  ijthdfwd=0.01
+ lodk2=1.0  xj=1.6e-07  ijthsrev=0.01
+ cle=0.6  aigbinv=0.35  njtsswg=11.6
+ tnom=25.0  ndep=5.8e+17  mjs=0.359
+ cgidl=0.25  eigbinv=1.1  xjbvd=1.0
+ phin=0.0  prwg=0.0  nsd=1e+20
+ toxref=3e-09  wwlc=0.0  mjswgs=0.541
+ lw=0.0  bigbacc=0.006537  agidl=2.593e-09
+ wpemod=1.0  dwc=0.0  cgdl=1e-10
+ tpbswg=0.00133  wint=1.02e-08  jswgd=6.9e-13
+ xgw=0.0  a2=0.995  dvtp0=1.46e-06
+ lpe0=9.921e-09  kt1l=0.0  k1=0.448
+ gbmin=1e-12  dmcg=2.05e-07  paramchk=1.0
+ kvsat=0.4  tpb=0.00149  voffl=-1.22e-09
+ xpart=1.0  pbswd=0.32  pscbe1=450000000.0
+ wwl=0.0  cjswgd=3.82e-10  ngcon=1.0
+ mjd=0.359  dvt2=-0.6939  llodvth=1.0
+ pvag=0.6279  k2we=0.0038  diomod=1.0
+ sbref=1e-05  rdsw=200.0  tcj=0.000905
+ rdsmod=1.0  aigsd=0.008379  bvs=11.25
+ dtox=5.958e-10  bgidl=1850800000.0  prwb=0.0
+ wwn=1.0  cgsl=1e-10  moin=5.346
+ bvd=11.25  version=4.5  pditsd=0.0
+ scref=1e-06  bigsd=0.0002699  rdw=90.88
+ igcmod=0.0  b0=0.0  lwlc=0.0
+ fnoimod=1.0  toxm=3.981e-09  pdits=0.0
+ web=0.0  xjbvs=1.0  k3b=1.2
+ cjsws=1.185e-10  at=123508.84626839616  lat=-0.05003247561161752
+ wat=2.2175611200982035e-05  pat=-1.1229632833516749e-11  ua=-2.261786432228668e-09
+ lua=6.70513013093952e-16  wua=-3.525468853603945e-18  pua=1.5219947462334088e-24
+ ub=3.372148194660233e-18  lub=-6.600650990870829e-25  wub=3.354203307858563e-27
+ pub=-1.5090147815581719e-33  kvth0=2.1999999880617516e-09  lkvth0=-1.0000000000000002e-08
+ wkvth0=2.2e-06  pkvth0=-4.999999999999994e-14  pdiblc2=0.002375536819114061
+ lpdiblc2=-4.0203322985337895e-10  wpdiblc2=1.2679110359676101e-12  ppdiblc2=-7.448425006101468e-19
+ nfactor=1.0326253322697472  lnfactor=-8.210943496899993e-08  wnfactor=-4.81630254848504e-10
+ pnfactor=-1.8922487888237412e-18  width=0.00091006  lwidth=0.0
+ wwidth=-9.0273009e-09  pwidth=-0.0  cit=-0.00045106432762584295
+ lcit=5.011034136618766e-10  wcit=-1.2507998620823015e-12  pcit=7.291743305213549e-19
+ length=1.7e-06  llength=-6.000000000000001e-13  wlength=-0.0
+ plength=-0.0  u0=0.021379404541945785  lu0=5.225441577804384e-09
+ wu0=-2.4537854823387035e-11  pu0=1.0834480050623694e-17  tvoff=0.0015084442907566812
+ ltvoff=-1.0133158597528886e-11  wtvoff=2.905429569148385e-13  ptvoff=-3.399306974997416e-19
+ ags=0.8547971126992053  lags=-1.692384338900971e-07  wags=1.1907468411248912e-10
+ pags=-4.609142758977087e-16  ute=-1.3793409130733894  lute=5.864293205808146e-08
+ wute=-1.702646247941282e-10  pute=8.743064101417112e-17  ku0=-3.200000008655754e-08
+ lku0=2.0000000000000007e-07  wku0=6.999999999999999e-07  pku0=-4.999999999999994e-14
+ voff=-0.11969288133393097  lvoff=-9.75445315749968e-09  wvoff=3.598030861337649e-11
+ pvoff=-1.801313642113781e-17  eta0=0.28430341597762077  leta0=1.6133213444467442e-09
+ weta0=-2.0809123642538476e-11  peta0=-1.599624957262735e-17  kt1=-0.266043778582746
+ lkt1=7.647300015494119e-10  wkt1=-4.261266327112629e-11  pkt1=1.990212606602851e-17
+ kt2=-0.054659619443616574  lkt2=-2.2455348259904337e-10  wkt2=1.530734509956225e-12
+ pkt2=-1.4634239244291283e-18  kvth0we=0.0035002690487056583  lkvth0we=-1.4304449781794187e-10
+ wkvth0we=1.4022517963707082e-14  pkvth0we=-1.739300390236625e-20  vth0=0.4238521782595884
+ lvth0=1.4180636722058063e-08  wvth0=-4.729234867031325e-11  pvth0=2.1439433757142467e-17
+ a0=1.650736812696497  la0=-5.962202739556135e-07  wa0=1.120039057708915e-09
+ pa0=-8.299318969823875e-16  keta=-0.114998425526187  lketa=1.4025944376146311e-08
+ wketa=-9.570105020142406e-11  pketa=4.360863618101578e-17  uc1=-2.2493093669564593e-10
+ luc1=1.1150939529737282e-16  wuc1=-3.933941742789809e-19  puc1=1.8112697327946655e-25
+ ub1=-5.161117386589827e-18  lub1=7.706878475857845e-25  wub1=-1.8667742361783205e-27
+ pub1=8.845237056554941e-34  ua1=3.1927494863685834e-09  lua1=-1.6780000897204732e-16
+ wua1=2.1734694810487824e-19  pua1=-4.901250536480471e-26  pclm=0.6159835009705106
+ lpclm=1.967808771494359e-08  wpclm=-6.618995136377891e-11  ppclm=2.598455968757924e-17
+ k2=0.04586609837041971  lk2=-2.4707237093843192e-09  wk2=5.651810654645435e-12
+ pk2=-1.5936072324219271e-18  vsat=81748.66846973423  lvsat=-0.008877395051113946
+ wvsat=1.4299144387053025e-05  pvsat=-1.1680101062882044e-11  uc=1.6191496173086882e-10
+ luc=-2.2236360738705478e-17  wuc=1.321609090286962e-19  puc=-8.239505435545056e-26
+ lmin=5e-007  lmax=1.2e-006  wmin=1.003e-005
+ wmax=90.003e-05

    4:  type=n
+ drout=0.5  saref=1e-05  pbsws=0.32
+ llc=0.0  pdiblcb=0.0  xw=0.0
+ cdsc=0.0  clc=1e-07  minv=-0.34
+ pbswgd=0.952  cdscb=0.0  toxe=3.981e-09
+ cjd=1e-10  cjswgs=3.82e-10  binunit=2.0
+ jtsswgs=1.09e-09  cigsd=3.925e-20  wlodku0=1.0
+ tpbsw=0.000894  rsw=90.88  njd=1.0
+ w0=0.0  pdiblc1=0.0  dwb=0.0
+ igbmod=0.0  dmdg=0.0  delta=0.005
+ wlodvth=1.0  etab=-0.308  permod=1.0
+ tnjtsswg=1.08  dlcig=2.5e-09  rshg=8.23
+ xgl=-3.1e-08  acde=0.4  capmod=2.0
+ noia=1.25e+42  tcjswg=0.00088  cgdo=1e-10
+ rbdb=50.0  cigbinv=0.006  jswgs=6.9e-13
+ wlod=5e-07  xrcrg2=1.0  jsd=2.85e-07
+ prt=0.0  minr=0.001  dmci=3.15e-07
+ ww=0.0  cigbacc=0.2809  wlc=0.0
+ dwj=0.0  dvt1w=0.0  mjswgd=0.541
+ aigbacc=0.01213  beta0=17.8  a1=0.0
+ alpha0=1.454e-07  dvt0=0.09708  lln=1.0
+ aigc=0.01  trnqsmod=0.0  cjs=1e-10
+ lodeta0=2.0  cf=1.0  ijthsfwd=0.01
+ ckappad=0.6  rbsb=50.0  xtsswgd=0.2886
+ ud=0.0  epsrox=3.9  rbpd=50.0
+ tempmod=0.0  alpha1=2.295  pbd=0.6882682
+ xtid=3.0  acnqsmod=0.0  nigbacc=4.05
+ rgatemod=0.0  cgbo=0.0  rsh=7.28
+ jtsswgd=1.09e-09  ngate=9e+19  tcjsw=0.000809
+ poxedge=1.0  xtsswgs=0.2886  mjswd=0.202
+ xrcrg1=12.0  pditsl=0.0  noff=1.973
+ lpeb=2.178e-08  ckappas=0.6  noib=7e+23
+ dmcgt=0.0  dsub=0.633  ll=0.0
+ cgso=1e-10  vtsswgs=10.0  jss=2.85e-07
+ ntox=1.0  dvtp1=0.0  mobmod=0.0
+ njs=1.0  cigc=1.515e-05  cjswd=1.185e-10
+ voffcv=-0.0904  mjsws=0.202  nigbinv=1.0
+ xl=-1.5e-08  ef=0.904  wl=0.0
+ rbodymod=0.0  lwc=0.0  wr=1.0
+ jswd=6.9e-13  pbs=0.6882682  dvt2w=0.0
+ wln=1.0  cdscd=0.0  ijthdrev=0.01
+ dvt0w=0.0  jsws=6.9e-13  nigc=1.0
+ b1=0.0  lint=2.595e-08  rbpb=50.0
+ noic=60800000.0  egidl=0.2624  wwc=0.0
+ dlc=2.595e-08  pbswgs=0.952  vtsswgd=10.0
+ fprout=0.0  lwn=1.0  lwl=0.0
+ ku0we=0.0  rgeomod=1.0  rbps=50.0
+ stk2=2.5e-09  k3=-3.7  dwg=0.0
+ bigc=0.00144  llodku0=1.0  bigbinv=0.03
+ tku0=0.03  xtis=3.0  steta0=-1.1e-10
+ wec=0.0  pscbe2=1e-20  pigcd=2.171
+ dvt1=0.3053  em=30000000.0  ijthdfwd=0.01
+ lodk2=1.0  xj=1.6e-07  ijthsrev=0.01
+ cle=0.6  aigbinv=0.35  njtsswg=11.6
+ tnom=25.0  ndep=5.8e+17  mjs=0.359
+ cgidl=0.25  eigbinv=1.1  xjbvd=1.0
+ phin=0.0  prwg=0.0  nsd=1e+20
+ toxref=3e-09  wwlc=0.0  mjswgs=0.541
+ lw=0.0  bigbacc=0.006537  agidl=2.593e-09
+ wpemod=1.0  dwc=0.0  cgdl=1e-10
+ tpbswg=0.00133  wint=1.02e-08  jswgd=6.9e-13
+ xgw=0.0  a2=0.995  dvtp0=1.46e-06
+ lpe0=9.921e-09  kt1l=0.0  k1=0.448
+ gbmin=1e-12  dmcg=2.05e-07  paramchk=1.0
+ kvsat=0.4  tpb=0.00149  voffl=-1.22e-09
+ xpart=1.0  pbswd=0.32  pscbe1=450000000.0
+ wwl=0.0  cjswgd=3.82e-10  ngcon=1.0
+ mjd=0.359  dvt2=-0.6939  llodvth=1.0
+ pvag=0.6279  k2we=0.0038  diomod=1.0
+ sbref=1e-05  rdsw=200.0  tcj=0.000905
+ rdsmod=1.0  aigsd=0.008379  bvs=11.25
+ dtox=5.958e-10  bgidl=1850800000.0  prwb=0.0
+ wwn=1.0  cgsl=1e-10  moin=5.346
+ bvd=11.25  version=4.5  pditsd=0.0
+ scref=1e-06  bigsd=0.0002699  rdw=90.88
+ igcmod=0.0  b0=0.0  lwlc=0.0
+ fnoimod=1.0  toxm=3.981e-09  pdits=0.0
+ web=0.0  xjbvs=1.0  k3b=1.2
+ cjsws=1.185e-10  at=26309.157037708206  lat=-0.0014326309962735442
+ wat=-7.230239945737901e-07  pat=2.1968476427961207e-13  ua=-8.747707733884339e-10
+ lua=-2.299481632616503e-17  wua=-5.636879483836766e-19  pua=4.1104293623274854e-26
+ ub=1.729803056530021e-18  lub=1.6110746997802315e-25  wub=1.5444062888732478e-28
+ pub=9.086655792744718e-35  kvth0=2.1999999708768432e-09  lkvth0=-9.999999999999995e-09
+ wkvth0=2.2000000000000005e-06  pkvth0=-5.000000000000012e-14  pdiblc2=0.001518433919246313
+ lpdiblc2=2.6518220080495148e-11  wpdiblc2=-5.643717436449426e-13  ppdiblc2=1.7129888919612953e-19
+ nfactor=0.8086922732634605  lnfactor=2.985709453414341e-08  wnfactor=-5.786751528224971e-10
+ pnfactor=4.663020019817287e-17  width=0.00091006  lwidth=0.0
+ wwidth=-9.0273009e-09  pwidth=-0.0  cit=0.000502828209808427
+ lcit=2.4157144944741537e-11  wcit=5.6002407412934343e-14  pcit=7.577319577373705e-20
+ length=6.8e-07  llength=-9e-14  wlength=-0.0
+ plength=-0.0  u0=0.029917032837237803  lu0=9.56627430158376e-10
+ wu0=-5.464633666970631e-12  pu0=1.2978694724154925e-18  tvoff=0.0013417544344485168
+ ltvoff=7.32117695565535e-11  wtvoff=-4.880511826839374e-13  ptvoff=4.9366372299646324e-20
+ ags=0.37396254083493674  lags=7.117885204203721e-08  wags=-1.148570977541016e-09
+ pags=1.7290855492904376e-16  ute=-1.2670469368111767  lute=2.4959439269749983e-09
+ wute=-2.0519062412198722e-11  pute=1.255785982320639e-17  ku0=-3.19999999428514e-08
+ lku0=2e-07  wku0=7.000000000000004e-07  pku0=-5.0000000000000203e-14
+ voff=-0.1431887207068978  lvoff=1.9934665289837397e-09  wvoff=-3.442031690213563e-12
+ pvoff=1.698033730657215e-18  eta0=0.28753007575881734  leta0=-8.546151557342923e-15
+ weta0=-6.818520836010375e-11  peta0=7.691792786155285e-18  kt1=-0.2543050748466977
+ lkt1=-5.10462186647476e-09  wkt1=3.377765502373071e-12  pkt1=-3.093088320721172e-18
+ kt2=-0.05506074727664949  lkt2=-2.3989566082584644e-11  wkt2=-1.6635709086794507e-12
+ pkt2=1.3372878488870944e-19  kvth0we=0.003499879937483461  lkvth0we=-1.4284994220684322e-10
+ wkvth0we=1.4077853385130199e-14  pkvth0we=-1.7420671613077808e-20  vth0=0.4576422171724722
+ lvth0=-2.7143827343838764e-09  wvth0=-4.2053652090324374e-12  pvth0=-1.0405797349793826e-19
+ a0=0.3548359587056988  la0=5.173015303978546e-08  wa0=-6.212620869080288e-10
+ pa0=4.071867532664737e-17  keta=-0.09704964846780828  lketa=5.051555846956949e-09
+ wketa=-8.973021632925462e-12  pketa=2.4462189676648655e-19  uc1=-2.5135846360532773e-11
+ luc1=1.1611850129816247e-17  wuc1=-6.900594562183902e-20  puc1=1.8932858950836224e-26
+ ub1=-3.4697804627014925e-18  lub1=-7.498061435838298e-26  wub1=1.8581253659574814e-28
+ pub1=-1.417696807315401e-34  ua1=2.723897953360859e-09  lua1=6.662575753181508e-17
+ wua1=-1.3381048285085267e-19  pua1=1.2656621011306073e-25  pclm=0.6451314063089675
+ lpclm=5.104135045715048e-09  wpclm=-5.602368831964647e-11  ppclm=2.0901428165513024e-17
+ k2=0.040287717182418095  lk2=3.1846688461648414e-10  wk2=4.26565339335087e-12
+ pk2=-9.005286017746448e-19  vsat=63173.73064761192  lvsat=0.0004100738599472139
+ wvsat=-1.00050592194962e-05  pvsat=4.720007403925665e-13  uc=8.658424138622487e-11
+ luc=1.5428999433616485e-17  wuc=-5.1199308991687953e-20  puc=9.285054654741502e-27
+ lmin=1.8e-07  lmax=5e-007  wmin=1.003e-005
+ wmax=90.003e-05

    5:  type=n
+ drout=0.5  saref=1e-05  pbsws=0.32
+ llc=0.0  pdiblcb=0.0  xw=0.0
+ cdsc=0.0  clc=1e-07  minv=-0.34
+ pbswgd=0.952  cdscb=0.0  toxe=3.981e-09
+ cjd=1e-10  cjswgs=3.82e-10  binunit=2.0
+ jtsswgs=1.09e-09  cigsd=3.925e-20  wlodku0=1.0
+ tpbsw=0.000894  rsw=90.88  njd=1.0
+ w0=0.0  pdiblc1=0.0  dwb=0.0
+ igbmod=0.0  dmdg=0.0  delta=0.005
+ wlodvth=1.0  etab=-0.308  permod=1.0
+ tnjtsswg=1.08  dlcig=2.5e-09  rshg=8.23
+ xgl=-3.1e-08  acde=0.4  capmod=2.0
+ noia=1.25e+42  tcjswg=0.00088  cgdo=1e-10
+ rbdb=50.0  cigbinv=0.006  jswgs=6.9e-13
+ wlod=5e-07  xrcrg2=1.0  jsd=2.85e-07
+ prt=0.0  minr=0.001  dmci=3.15e-07
+ ww=0.0  cigbacc=0.2809  wlc=0.0
+ dwj=0.0  dvt1w=0.0  mjswgd=0.541
+ aigbacc=0.01213  beta0=17.8  a1=0.0
+ alpha0=1.454e-07  dvt0=0.09708  lln=1.0
+ aigc=0.01  trnqsmod=0.0  cjs=1e-10
+ lodeta0=2.0  cf=1.0  ijthsfwd=0.01
+ ckappad=0.6  rbsb=50.0  xtsswgd=0.2886
+ ud=0.0  epsrox=3.9  rbpd=50.0
+ tempmod=0.0  alpha1=2.295  pbd=0.6882682
+ xtid=3.0  acnqsmod=0.0  nigbacc=4.05
+ rgatemod=0.0  cgbo=0.0  rsh=7.28
+ jtsswgd=1.09e-09  ngate=9e+19  tcjsw=0.000809
+ poxedge=1.0  xtsswgs=0.2886  mjswd=0.202
+ xrcrg1=12.0  pditsl=0.0  noff=1.973
+ lpeb=2.178e-08  ckappas=0.6  noib=7e+23
+ dmcgt=0.0  dsub=0.633  ll=0.0
+ cgso=1e-10  vtsswgs=10.0  jss=2.85e-07
+ ntox=1.0  dvtp1=0.0  mobmod=0.0
+ njs=1.0  cigc=1.515e-05  cjswd=1.185e-10
+ voffcv=-0.0904  mjsws=0.202  nigbinv=1.0
+ xl=-1.5e-08  ef=0.904  wl=0.0
+ rbodymod=0.0  lwc=0.0  wr=1.0
+ jswd=6.9e-13  pbs=0.6882682  dvt2w=0.0
+ wln=1.0  cdscd=0.0  ijthdrev=0.01
+ dvt0w=0.0  jsws=6.9e-13  nigc=1.0
+ b1=0.0  lint=2.595e-08  rbpb=50.0
+ noic=60800000.0  egidl=0.2624  wwc=0.0
+ dlc=2.595e-08  pbswgs=0.952  vtsswgd=10.0
+ fprout=0.0  lwn=1.0  lwl=0.0
+ ku0we=0.0  rgeomod=1.0  rbps=50.0
+ stk2=2.5e-09  k3=-3.7  dwg=0.0
+ bigc=0.00144  llodku0=1.0  bigbinv=0.03
+ tku0=0.03  xtis=3.0  steta0=-1.1e-10
+ wec=0.0  pscbe2=1e-20  pigcd=2.171
+ dvt1=0.3053  em=30000000.0  ijthdfwd=0.01
+ lodk2=1.0  xj=1.6e-07  ijthsrev=0.01
+ cle=0.6  aigbinv=0.35  njtsswg=11.6
+ tnom=25.0  ndep=5.8e+17  mjs=0.359
+ cgidl=0.25  eigbinv=1.1  xjbvd=1.0
+ phin=0.0  prwg=0.0  nsd=1e+20
+ toxref=3e-09  wwlc=0.0  mjswgs=0.541
+ lw=0.0  bigbacc=0.006537  agidl=2.593e-09
+ wpemod=1.0  dwc=0.0  cgdl=1e-10
+ tpbswg=0.00133  wint=1.02e-08  jswgd=6.9e-13
+ xgw=0.0  a2=0.995  dvtp0=1.46e-06
+ lpe0=9.921e-09  kt1l=0.0  k1=0.448
+ gbmin=1e-12  dmcg=2.05e-07  paramchk=1.0
+ kvsat=0.4  tpb=0.00149  voffl=-1.22e-09
+ xpart=1.0  pbswd=0.32  pscbe1=450000000.0
+ wwl=0.0  cjswgd=3.82e-10  ngcon=1.0
+ mjd=0.359  dvt2=-0.6939  llodvth=1.0
+ pvag=0.6279  k2we=0.0038  diomod=1.0
+ sbref=1e-05  rdsw=200.0  tcj=0.000905
+ rdsmod=1.0  aigsd=0.008379  bvs=11.25
+ dtox=5.958e-10  bgidl=1850800000.0  prwb=0.0
+ wwn=1.0  cgsl=1e-10  moin=5.346
+ bvd=11.25  version=4.5  pditsd=0.0
+ scref=1e-06  bigsd=0.0002699  rdw=90.88
+ igcmod=0.0  b0=0.0  lwlc=0.0
+ fnoimod=1.0  toxm=3.981e-09  pdits=0.0
+ web=0.0  xjbvs=1.0  k3b=1.2
+ cjsws=1.185e-10  at=117035.39976409091  lat=0.0003121180136364072
+ wat=0.007981636629168204  pat=1.8048706322706796e-10  ua=-1.2044086850068178e-09
+ lua=6.239241045449863e-18  wua=9.253634061758858e-16  pua=-1.1172698835901774e-23
+ ub=2.4236038636835228e-18  lub=-5.213158897727506e-27  wub=-9.728272588832331e-25
+ pub=9.326226494204191e-33  kvth0=2.1999999305135114e-09  lkvth0=-9.999999999999618e-09
+ wkvth0=2.2000000000000005e-06  pkvth0=-5.000000000000349e-14  pdiblc2=0.0009719355308329545
+ lpdiblc2=-9.973868931817206e-12  wpdiblc2=3.5412221970466247e-11  ppdiblc2=5.82206788613449e-18
+ nfactor=0.8865174311559944  lnfactor=-2.5403221079608516e-10  wnfactor=6.333382848208765e-07
+ pnfactor=1.408809764282962e-15  width=1.126e-05  lwidth=-0.0
+ wwidth=-1.2336900000000002e-11  pwidth=-0.0  cit=0.0007988570972159091
+ lcit=7.84631931818225e-12  wcit=2.9363155982443207e-10  pcit=-2.83503776136696e-18
+ length=3e-05  llength=-2.0000000000000003e-10  wlength=3.1128887346586584e-27
+ plength=-3.1128887346586585e-32  u0=0.02997789320966477  lu0=5.0017533977285113e-11
+ wu0=5.471189501712335e-09  pu0=-8.487275879207165e-17  tvoff=0.0014999999080377842
+ ltvoff=1.839244318118892e-15  wtvoff=9.223810255366244e-16  ptvoff=-1.844762051073249e-20
+ ags=0.5059684594196023  lags=-1.5769743011354348e-09  wags=-5.165562066861084e-08
+ pags=-2.8598569596033773e-15  ute=-1.8450015913843751  lute=-4.5041723124976275e-09
+ wute=3.359141828977816e-07  pute=2.1566920443741394e-15  ku0=-3.1999999988794484e-08
+ lku0=1.9999999999999967e-07  wku0=6.999999999999999e-07  pku0=-4.999999999999727e-14
+ voff=-0.12992512938153697  lvoff=-3.4664869260775014e-11  wvoff=-6.249799765309496e-09
+ pvoff=1.2288188119047376e-16  eta0=0.21624162669170452  leta0=-5.86470652272599e-10
+ weta0=1.1517087987245352e-07  peta0=7.13349837294361e-16  kt1=-0.24973474075286933
+ lkt1=1.616728982954958e-10  wkt1=3.6174899787029314e-08  pkt1=9.81351150961899e-17
+ kt2=-0.055217782527968745  lkt2=-3.4990542615084077e-12  wkt2=2.644517389565428e-10
+ pkt2=4.81064564178567e-18  kvth0we=0.003493924248619034  lkvth0we=1.0360298920470426e-12
+ wkvth0we=-1.2644242156412038e-11  pkvth0we=-1.2085966721270177e-19  vth0=0.43765503096287206
+ lvth0=4.0147219830343805e-11  wvth0=1.877111429814236e-08  pvth0=-8.556172989105143e-17
+ a0=1.0647178322609376  la0=-1.0323179460228308e-09  wa0=7.728033446654722e-08
+ pa0=4.246308123603725e-15  keta=-0.05345296901715909  lketa=4.912525022727219e-10
+ wketa=2.0591271196105683e-08  pketa=-3.257292777954736e-16  uc1=-8.771475441874999e-11
+ luc1=5.793010681816931e-19  wuc1=7.007027790256248e-17  puc1=-1.4567669638633393e-24
+ ub1=-4.450984700854687e-18  lub1=1.4207716392026805e-27  wub1=2.111952798062644e-25
+ pub1=-7.800034216219365e-33  ua1=2.3108648656005684e-09  lua1=-6.719527920455451e-18
+ wua1=3.1047463473130145e-16  pua1=4.279570942155085e-24  pclm=0.7264599138704546
+ lpclm=8.707635000000255e-10  wpclm=-7.64332160506592e-08  ppclm=-1.0621433049997343e-15
+ k2=0.04409903603215625  lk2=-6.464840341098058e-13  wk2=2.431895506942816e-09
+ pk2=5.884984546189493e-17  vsat=73828.65358330113  lvsat=-6.687120568137538e-06
+ wvsat=-0.005002948924460389  pvsat=-6.680301701106742e-12  uc=2.0893196237656253e-10
+ luc=5.330994232952466e-19  wuc=-1.7318003098017193e-16  puc=-1.0015213506529913e-24
+ lmin=1e-005  lmax=2e-05  wmin=1.23e-006
+ wmax=1.003e-005

    6:  type=n
+ drout=0.5  saref=1e-05  pbsws=0.32
+ llc=0.0  pdiblcb=0.0  xw=0.0
+ cdsc=0.0  clc=1e-07  minv=-0.34
+ pbswgd=0.952  cdscb=0.0  toxe=3.981e-09
+ cjd=1e-10  cjswgs=3.82e-10  binunit=2.0
+ jtsswgs=1.09e-09  cigsd=3.925e-20  wlodku0=1.0
+ tpbsw=0.000894  rsw=90.88  njd=1.0
+ w0=0.0  pdiblc1=0.0  dwb=0.0
+ igbmod=0.0  dmdg=0.0  delta=0.005
+ wlodvth=1.0  etab=-0.308  permod=1.0
+ tnjtsswg=1.08  dlcig=2.5e-09  rshg=8.23
+ xgl=-3.1e-08  acde=0.4  capmod=2.0
+ noia=1.25e+42  tcjswg=0.00088  cgdo=1e-10
+ rbdb=50.0  cigbinv=0.006  jswgs=6.9e-13
+ wlod=5e-07  xrcrg2=1.0  jsd=2.85e-07
+ prt=0.0  minr=0.001  dmci=3.15e-07
+ ww=0.0  cigbacc=0.2809  wlc=0.0
+ dwj=0.0  dvt1w=0.0  mjswgd=0.541
+ aigbacc=0.01213  beta0=17.8  a1=0.0
+ alpha0=1.454e-07  dvt0=0.09708  lln=1.0
+ aigc=0.01  trnqsmod=0.0  cjs=1e-10
+ lodeta0=2.0  cf=1.0  ijthsfwd=0.01
+ ckappad=0.6  rbsb=50.0  xtsswgd=0.2886
+ ud=0.0  epsrox=3.9  rbpd=50.0
+ tempmod=0.0  alpha1=2.295  pbd=0.6882682
+ xtid=3.0  acnqsmod=0.0  nigbacc=4.05
+ rgatemod=0.0  cgbo=0.0  rsh=7.28
+ jtsswgd=1.09e-09  ngate=9e+19  tcjsw=0.000809
+ poxedge=1.0  xtsswgs=0.2886  mjswd=0.202
+ xrcrg1=12.0  pditsl=0.0  noff=1.973
+ lpeb=2.178e-08  ckappas=0.6  noib=7e+23
+ dmcgt=0.0  dsub=0.633  ll=0.0
+ cgso=1e-10  vtsswgs=10.0  jss=2.85e-07
+ ntox=1.0  dvtp1=0.0  mobmod=0.0
+ njs=1.0  cigc=1.515e-05  cjswd=1.185e-10
+ voffcv=-0.0904  mjsws=0.202  nigbinv=1.0
+ xl=-1.5e-08  ef=0.904  wl=0.0
+ rbodymod=0.0  lwc=0.0  wr=1.0
+ jswd=6.9e-13  pbs=0.6882682  dvt2w=0.0
+ wln=1.0  cdscd=0.0  ijthdrev=0.01
+ dvt0w=0.0  jsws=6.9e-13  nigc=1.0
+ b1=0.0  lint=2.595e-08  rbpb=50.0
+ noic=60800000.0  egidl=0.2624  wwc=0.0
+ dlc=2.595e-08  pbswgs=0.952  vtsswgd=10.0
+ fprout=0.0  lwn=1.0  lwl=0.0
+ ku0we=0.0  rgeomod=1.0  rbps=50.0
+ stk2=2.5e-09  k3=-3.7  dwg=0.0
+ bigc=0.00144  llodku0=1.0  bigbinv=0.03
+ tku0=0.03  xtis=3.0  steta0=-1.1e-10
+ wec=0.0  pscbe2=1e-20  pigcd=2.171
+ dvt1=0.3053  em=30000000.0  ijthdfwd=0.01
+ lodk2=1.0  xj=1.6e-07  ijthsrev=0.01
+ cle=0.6  aigbinv=0.35  njtsswg=11.6
+ tnom=25.0  ndep=5.8e+17  mjs=0.359
+ cgidl=0.25  eigbinv=1.1  xjbvd=1.0
+ phin=0.0  prwg=0.0  nsd=1e+20
+ toxref=3e-09  wwlc=0.0  mjswgs=0.541
+ lw=0.0  bigbacc=0.006537  agidl=2.593e-09
+ wpemod=1.0  dwc=0.0  cgdl=1e-10
+ tpbswg=0.00133  wint=1.02e-08  jswgd=6.9e-13
+ xgw=0.0  a2=0.995  dvtp0=1.46e-06
+ lpe0=9.921e-09  kt1l=0.0  k1=0.448
+ gbmin=1e-12  dmcg=2.05e-07  paramchk=1.0
+ kvsat=0.4  tpb=0.00149  voffl=-1.22e-09
+ xpart=1.0  pbswd=0.32  pscbe1=450000000.0
+ wwl=0.0  cjswgd=3.82e-10  ngcon=1.0
+ mjd=0.359  dvt2=-0.6939  llodvth=1.0
+ pvag=0.6279  k2we=0.0038  diomod=1.0
+ sbref=1e-05  rdsw=200.0  tcj=0.000905
+ rdsmod=1.0  aigsd=0.008379  bvs=11.25
+ dtox=5.958e-10  bgidl=1850800000.0  prwb=0.0
+ wwn=1.0  cgsl=1e-10  moin=5.346
+ bvd=11.25  version=4.5  pditsd=0.0
+ scref=1e-06  bigsd=0.0002699  rdw=90.88
+ igcmod=0.0  b0=0.0  lwlc=0.0
+ fnoimod=1.0  toxm=3.981e-09  pdits=0.0
+ web=0.0  xjbvs=1.0  k3b=1.2
+ cjsws=1.185e-10  at=121702.66909860537  lat=-0.04636057533150825
+ wat=0.010803577687294941  pat=-2.8038923518040304e-08  ua=-1.1055640379070894e-09
+ lua=-9.822072299518335e-16  wua=7.482589353529929e-16  pua=1.759872009393028e-21
+ ub=2.3407206394143857e-18  lub=8.236190837936462e-25  wub=-8.243604650194669e-25
+ pub=-1.4753417121434577e-30  kvth0=2.199999982430384e-09  lkvth0=-9.999999999999992e-09
+ wkvth0=2.2e-06  pkvth0=-4.999999999999995e-14  pdiblc2=0.0008164475124672004
+ lpdiblc2=1.544906314725723e-09  wpdiblc2=1.2747413342898003e-10  ppdiblc2=-9.147970466990034e-16
+ nfactor=0.882360483575155  lnfactor=4.1315443597598124e-08  wnfactor=6.550835590525593e-07
+ pnfactor=-2.1604393255254545e-13  width=1.126e-05  lwidth=0.0
+ wwidth=-1.2336900000000002e-11  pwidth=0.0  cit=0.0009218006926869512
+ lcit=-1.2215896353922392e-09  wcit=2.4766414187033404e-10  pcit=4.568391417796135e-16
+ length=1.1200000000000001e-05  llength=-1.2e-11  wlength=0.0
+ plength=0.0  u0=0.03076989424176459  lu0=-7.869992787020919e-09
+ wu0=4.12754097180569e-09  pu0=1.3351612540274367e-14  tvoff=0.0014999304661198994
+ ltvoff=6.962584231663618e-13  wtvoff=6.964448554784648e-13  ptvoff=-6.973672365040014e-18
+ ags=0.48099952229639087  lags=2.4811239693097854e-07  wags=-9.455647772086764e-08
+ pags=4.2614871356296467e-13  ute=-1.9143787098005876  lute=6.892670118496256e-07
+ wute=3.689613644126775e-07  pute=-3.2831512310458497e-13  ku0=-3.2000000024027666e-08
+ lku0=2e-07  wku0=7.000000000000002e-07  pku0=-5.0000000000000166e-14
+ voff=-0.1304942487152376  lvoff=5.6565284677453155e-09  wvoff=-4.299248989320278e-09
+ pvoff=-1.938262587870171e-14  eta0=0.207181932200962  leta0=9.001047425515243e-08
+ weta0=1.2623322508162352e-07  peta0=-1.0991010225440565e-13  kt1=-0.24723134737144886
+ lkt1=-2.4872260915909057e-08  wkt1=3.763247377412644e-08  pkt1=-1.4477604755875028e-14
+ kt2=-0.05527296403332581  lkt2=5.483159993091508e-10  wkt2=3.430249999452918e-10
+ pkt2=-7.809219642457047e-16  kvth0we=0.003509439123077544  lkvth0we=-1.541127146930522e-10
+ wkvth0we=-1.445521765526504e-11  pkvth0we=1.7988895321317313e-17  vth0=0.43832315814894107
+ lvth0=-6.641124640859929e-09  wvth0=1.7385379558450213e-08  pvth0=1.3771785667030423e-14
+ a0=1.0467520419708805  la0=1.7862558495454533e-07  wa0=1.4530440934456664e-07
+ pa0=-6.759944406565906e-13  keta=-0.04580685892509039  lketa=-7.596984841841425e-08
+ wketa=1.5430694225986183e-08  pketa=5.1280040423399535e-14  uc1=-7.837190378124355e-11
+ luc1=-9.284920530688273e-17  wuc1=4.70232629766682e-17  puc1=2.2901338229507944e-22
+ ub1=-4.426497528004584e-18  lub1=-2.4345095686182986e-25  wub1=8.81341793802964e-26
+ pub1=1.2228109700434604e-30  ua1=2.2065788059920584e-09  lua1=1.0361410681646434e-15
+ wua1=3.7668100103317725e-16  pua1=-6.577840920766027e-22  pclm=0.7399819207439631
+ lpclm=-1.343493052350853e-07  wpclm=-9.293075355967694e-08  ppclm=1.6391323178517765e-13
+ k2=0.0440812912788546  lk2=1.768010489824367e-10  wk2=3.3460626729179367e-09
+ pk2=-9.082821814289309e-15  vsat=73695.4178634814  lvsat=0.0013256700776291465
+ wvsat=-0.005072026076599159  pvsat=6.840912196865869e-10  uc=2.1708295678592458e-10
+ luc=-8.097684467032541e-17  wuc=-1.8841398801594864e-16  puc=1.5133804900711391e-22
+ lmin=1.2e-006  lmax=1e-005  wmin=1.23e-006
+ wmax=1.003e-005

    7:  type=n
+ drout=0.5  saref=1e-05  pbsws=0.32
+ llc=0.0  pdiblcb=0.0  xw=0.0
+ cdsc=0.0  clc=1e-07  minv=-0.34
+ pbswgd=0.952  cdscb=0.0  toxe=3.981e-09
+ cjd=1e-10  cjswgs=3.82e-10  binunit=2.0
+ jtsswgs=1.09e-09  cigsd=3.925e-20  wlodku0=1.0
+ tpbsw=0.000894  rsw=90.88  njd=1.0
+ w0=0.0  pdiblc1=0.0  dwb=0.0
+ igbmod=0.0  dmdg=0.0  delta=0.005
+ wlodvth=1.0  etab=-0.308  permod=1.0
+ tnjtsswg=1.08  dlcig=2.5e-09  rshg=8.23
+ xgl=-3.1e-08  acde=0.4  capmod=2.0
+ noia=1.25e+42  tcjswg=0.00088  cgdo=1e-10
+ rbdb=50.0  cigbinv=0.006  jswgs=6.9e-13
+ wlod=5e-07  xrcrg2=1.0  jsd=2.85e-07
+ prt=0.0  minr=0.001  dmci=3.15e-07
+ ww=0.0  cigbacc=0.2809  wlc=0.0
+ dwj=0.0  dvt1w=0.0  mjswgd=0.541
+ aigbacc=0.01213  beta0=17.8  a1=0.0
+ alpha0=1.454e-07  dvt0=0.09708  lln=1.0
+ aigc=0.01  trnqsmod=0.0  cjs=1e-10
+ lodeta0=2.0  cf=1.0  ijthsfwd=0.01
+ ckappad=0.6  rbsb=50.0  xtsswgd=0.2886
+ ud=0.0  epsrox=3.9  rbpd=50.0
+ tempmod=0.0  alpha1=2.295  pbd=0.6882682
+ xtid=3.0  acnqsmod=0.0  nigbacc=4.05
+ rgatemod=0.0  cgbo=0.0  rsh=7.28
+ jtsswgd=1.09e-09  ngate=9e+19  tcjsw=0.000809
+ poxedge=1.0  xtsswgs=0.2886  mjswd=0.202
+ xrcrg1=12.0  pditsl=0.0  noff=1.973
+ lpeb=2.178e-08  ckappas=0.6  noib=7e+23
+ dmcgt=0.0  dsub=0.633  ll=0.0
+ cgso=1e-10  vtsswgs=10.0  jss=2.85e-07
+ ntox=1.0  dvtp1=0.0  mobmod=0.0
+ njs=1.0  cigc=1.515e-05  cjswd=1.185e-10
+ voffcv=-0.0904  mjsws=0.202  nigbinv=1.0
+ xl=-1.5e-08  ef=0.904  wl=0.0
+ rbodymod=0.0  lwc=0.0  wr=1.0
+ jswd=6.9e-13  pbs=0.6882682  dvt2w=0.0
+ wln=1.0  cdscd=0.0  ijthdrev=0.01
+ dvt0w=0.0  jsws=6.9e-13  nigc=1.0
+ b1=0.0  lint=2.595e-08  rbpb=50.0
+ noic=60800000.0  egidl=0.2624  wwc=0.0
+ dlc=2.595e-08  pbswgs=0.952  vtsswgd=10.0
+ fprout=0.0  lwn=1.0  lwl=0.0
+ ku0we=0.0  rgeomod=1.0  rbps=50.0
+ stk2=2.5e-09  k3=-3.7  dwg=0.0
+ bigc=0.00144  llodku0=1.0  bigbinv=0.03
+ tku0=0.03  xtis=3.0  steta0=-1.1e-10
+ wec=0.0  pscbe2=1e-20  pigcd=2.171
+ dvt1=0.3053  em=30000000.0  ijthdfwd=0.01
+ lodk2=1.0  xj=1.6e-07  ijthsrev=0.01
+ cle=0.6  aigbinv=0.35  njtsswg=11.6
+ tnom=25.0  ndep=5.8e+17  mjs=0.359
+ cgidl=0.25  eigbinv=1.1  xjbvd=1.0
+ phin=0.0  prwg=0.0  nsd=1e+20
+ toxref=3e-09  wwlc=0.0  mjswgs=0.541
+ lw=0.0  bigbacc=0.006537  agidl=2.593e-09
+ wpemod=1.0  dwc=0.0  cgdl=1e-10
+ tpbswg=0.00133  wint=1.02e-08  jswgd=6.9e-13
+ xgw=0.0  a2=0.995  dvtp0=1.46e-06
+ lpe0=9.921e-09  kt1l=0.0  k1=0.448
+ gbmin=1e-12  dmcg=2.05e-07  paramchk=1.0
+ kvsat=0.4  tpb=0.00149  voffl=-1.22e-09
+ xpart=1.0  pbswd=0.32  pscbe1=450000000.0
+ wwl=0.0  cjswgd=3.82e-10  ngcon=1.0
+ mjd=0.359  dvt2=-0.6939  llodvth=1.0
+ pvag=0.6279  k2we=0.0038  diomod=1.0
+ sbref=1e-05  rdsw=200.0  tcj=0.000905
+ rdsmod=1.0  aigsd=0.008379  bvs=11.25
+ dtox=5.958e-10  bgidl=1850800000.0  prwb=0.0
+ wwn=1.0  cgsl=1e-10  moin=5.346
+ bvd=11.25  version=4.5  pditsd=0.0
+ scref=1e-06  bigsd=0.0002699  rdw=90.88
+ igcmod=0.0  b0=0.0  lwlc=0.0
+ fnoimod=1.0  toxm=3.981e-09  pdits=0.0
+ web=0.0  xjbvs=1.0  k3b=1.2
+ cjsws=1.185e-10  at=125685.83571400569  lat=-0.05114037526998865
+ wat=-0.02181302852826273  pat=1.1101003940628899e-08  ua=-2.607045860434253e-09
+ lua=8.19570957080763e-16  wua=3.459426596048418e-15  pua=-1.4935291834414818e-21
+ ub=3.6998616131939935e-18  lub=-8.07350084741883e-25  wub=-3.2836113845857553e-24
+ pub=1.4757593913360878e-30  kvth0=2.2000000006523496e-09  lkvth0=-9.999999999999984e-09
+ wkvth0=2.2e-06  pkvth0=-5.000000000000012e-14  pdiblc2=0.002499632003862419
+ lpdiblc2=-4.749150749485392e-10  wpdiblc2=-1.2434067919900614e-09  ppdiblc2=7.302600638038461e-16
+ nfactor=0.9853738667483766  lnfactor=-8.230061621026792e-08  wnfactor=4.734505689244973e-07
+ pnfactor=1.915655601129062e-15  width=1.126e-05  lwidth=0.0
+ wwidth=-1.2336900000000002e-11  pwidth=0.0  cit=-0.0005731320025502843
+ lcit=5.723295988924433e-10  wcit=1.2230879796300642e-09  pcit=-7.136694635320626e-16
+ length=1.7e-06  llength=-6.000000000000001e-13  wlength=0.0
+ plength=0.0  u0=0.01897027661199675  lu0=6.28954836870049e-09
+ wu0=2.4139015282565433e-08  pu0=-1.066215663263732e-14  tvoff=0.0015365759353543021
+ ltvoff=-4.327830465811691e-11  wtvoff=-2.8186985235722e-10  ptvoff=3.3210588429019803e-16
+ ags=0.8661739885154219  lags=-2.1409696253185877e-07  wags=-1.1399098975254052e-07
+ pags=4.49470128000972e-13  ute=-1.3960282122729504  lute=6.724641481646103e-08
+ wute=1.6720334634680078e-07  pute=-8.62055014255329e-14  ku0=-3.200000008655754e-08
+ lku0=2.0000000000000007e-07  wku0=7.000000000000001e-07  pku0=-4.999999999999999e-14
+ voff=-0.11617614783382713  lvoff=-1.1525192589947247e-08  wvoff=-3.5236856697428334e-08
+ pvoff=1.7742503371027956e-14  eta0=0.28209660161095784  leta0=1.1287096315742646e-10
+ weta0=2.2113538973986113e-08  peta0=1.5033521074759228e-14  kt1=-0.2702301235721996
+ lkt1=2.7262705249918296e-09  wkt1=4.1946427580948424e-08  pkt1=-1.9654349324061415e-14
+ kt2=-0.054509056887832794  lkt2=-3.683725752824648e-10  wkt2=-1.508611700001369e-09
+ pkt2=1.4410420756902877e-15  kvth0we=0.0035016206610836045  lkvth0we=-1.44730560300325e-10
+ wkvth0we=-1.3542649632834056e-11  pkvth0we=1.6893813694400127e-17  vth0=0.41921546106375823
+ lvth0=1.628811186135952e-08  wvth0=4.645898112550597e-08  pvth0=-2.1116536213436473e-14
+ a0=1.7599304360584416  la0=-6.771884879505277e-07  wa0=-1.0940920032625975e-06
+ pa0=8.112812544720061e-13  keta=-0.1243615002552354  lketa=1.8295721177759735e-08
+ wketa=9.381593848215384e-08  pketa=-4.278225268400162e-14  uc1=-2.6347726276221595e-10
+ luc1=1.2927722547028412e-16  wuc1=3.8622625627341857e-16  puc1=-1.780302096610209e-22
+ ub1=-5.344051476263394e-18  lub1=8.576137810487423e-25  wub1=1.8329621451896887e-24
+ pub1=-8.709825889278098e-31  ua1=3.2138626701505684e-09  lua1=-1.7259956882556813e-16
+ wua1=-2.115478863851992e-16  pua1=4.8090572825448956e-23  pclm=0.6094057171429382
+ lpclm=2.2342139086144512e-08  wpclm=6.590898183918587e-08  ppclm=-2.6694450693457687e-14
+ k2=0.046418278709062503  lk2=-2.627583867267045e-09  wk2=-5.532716985932589e-09
+ pk2=1.5717137763313213e-15  vsat=83146.22756734173  lvsat=-0.010015301567003254
+ wvsat=-0.014003218604616062  pvsat=1.1401522253306867e-08  uc=1.7484348045584415e-10
+ luc=-3.028947307422889e-17  wuc=-1.2954088190247405e-16  puc=8.069032167094439e-23
+ lmin=5e-007  lmax=1.2e-006  wmin=1.23e-006
+ wmax=1.003e-005

    8:  type=n
+ drout=0.5  saref=1e-05  pbsws=0.32
+ llc=0.0  pdiblcb=0.0  xw=0.0
+ cdsc=0.0  clc=1e-07  minv=-0.34
+ pbswgd=0.952  cdscb=0.0  toxe=3.981e-09
+ cjd=1e-10  cjswgs=3.82e-10  binunit=2.0
+ jtsswgs=1.09e-09  cigsd=3.925e-20  wlodku0=1.0
+ tpbsw=0.000894  rsw=90.88  njd=1.0
+ w0=0.0  pdiblc1=0.0  dwb=0.0
+ igbmod=0.0  dmdg=0.0  delta=0.005
+ wlodvth=1.0  etab=-0.308  permod=1.0
+ tnjtsswg=1.08  dlcig=2.5e-09  rshg=8.23
+ xgl=-3.1e-08  acde=0.4  capmod=2.0
+ noia=1.25e+42  tcjswg=0.00088  cgdo=1e-10
+ rbdb=50.0  cigbinv=0.006  jswgs=6.9e-13
+ wlod=5e-07  xrcrg2=1.0  jsd=2.85e-07
+ prt=0.0  minr=0.001  dmci=3.15e-07
+ ww=0.0  cigbacc=0.2809  wlc=0.0
+ dwj=0.0  dvt1w=0.0  mjswgd=0.541
+ aigbacc=0.01213  beta0=17.8  a1=0.0
+ alpha0=1.454e-07  dvt0=0.09708  lln=1.0
+ aigc=0.01  trnqsmod=0.0  cjs=1e-10
+ lodeta0=2.0  cf=1.0  ijthsfwd=0.01
+ ckappad=0.6  rbsb=50.0  xtsswgd=0.2886
+ ud=0.0  epsrox=3.9  rbpd=50.0
+ tempmod=0.0  alpha1=2.295  pbd=0.6882682
+ xtid=3.0  acnqsmod=0.0  nigbacc=4.05
+ rgatemod=0.0  cgbo=0.0  rsh=7.28
+ jtsswgd=1.09e-09  ngate=9e+19  tcjsw=0.000809
+ poxedge=1.0  xtsswgs=0.2886  mjswd=0.202
+ xrcrg1=12.0  pditsl=0.0  noff=1.973
+ lpeb=2.178e-08  ckappas=0.6  noib=7e+23
+ dmcgt=0.0  dsub=0.633  ll=0.0
+ cgso=1e-10  vtsswgs=10.0  jss=2.85e-07
+ ntox=1.0  dvtp1=0.0  mobmod=0.0
+ njs=1.0  cigc=1.515e-05  cjswd=1.185e-10
+ voffcv=-0.0904  mjsws=0.202  nigbinv=1.0
+ xl=-1.5e-08  ef=0.904  wl=0.0
+ rbodymod=0.0  lwc=0.0  wr=1.0
+ jswd=6.9e-13  pbs=0.6882682  dvt2w=0.0
+ wln=1.0  cdscd=0.0  ijthdrev=0.01
+ dvt0w=0.0  jsws=6.9e-13  nigc=1.0
+ b1=0.0  lint=2.595e-08  rbpb=50.0
+ noic=60800000.0  egidl=0.2624  wwc=0.0
+ dlc=2.595e-08  pbswgs=0.952  vtsswgd=10.0
+ fprout=0.0  lwn=1.0  lwl=0.0
+ ku0we=0.0  rgeomod=1.0  rbps=50.0
+ stk2=2.5e-09  k3=-3.7  dwg=0.0
+ bigc=0.00144  llodku0=1.0  bigbinv=0.03
+ tku0=0.03  xtis=3.0  steta0=-1.1e-10
+ wec=0.0  pscbe2=1e-20  pigcd=2.171
+ dvt1=0.3053  em=30000000.0  ijthdfwd=0.01
+ lodk2=1.0  xj=1.6e-07  ijthsrev=0.01
+ cle=0.6  aigbinv=0.35  njtsswg=11.6
+ tnom=25.0  ndep=5.8e+17  mjs=0.359
+ cgidl=0.25  eigbinv=1.1  xjbvd=1.0
+ phin=0.0  prwg=0.0  nsd=1e+20
+ toxref=3e-09  wwlc=0.0  mjswgs=0.541
+ lw=0.0  bigbacc=0.006537  agidl=2.593e-09
+ wpemod=1.0  dwc=0.0  cgdl=1e-10
+ tpbswg=0.00133  wint=1.02e-08  jswgd=6.9e-13
+ xgw=0.0  a2=0.995  dvtp0=1.46e-06
+ lpe0=9.921e-09  kt1l=0.0  k1=0.448
+ gbmin=1e-12  dmcg=2.05e-07  paramchk=1.0
+ kvsat=0.4  tpb=0.00149  voffl=-1.22e-09
+ xpart=1.0  pbswd=0.32  pscbe1=450000000.0
+ wwl=0.0  cjswgd=3.82e-10  ngcon=1.0
+ mjd=0.359  dvt2=-0.6939  llodvth=1.0
+ pvag=0.6279  k2we=0.0038  diomod=1.0
+ sbref=1e-05  rdsw=200.0  tcj=0.000905
+ rdsmod=1.0  aigsd=0.008379  bvs=11.25
+ dtox=5.958e-10  bgidl=1850800000.0  prwb=0.0
+ wwn=1.0  cgsl=1e-10  moin=5.346
+ bvd=11.25  version=4.5  pditsd=0.0
+ scref=1e-06  bigsd=0.0002699  rdw=90.88
+ igcmod=0.0  b0=0.0  lwlc=0.0
+ fnoimod=1.0  toxm=3.981e-09  pdits=0.0
+ web=0.0  xjbvs=1.0  k3b=1.2
+ cjsws=1.185e-10  at=26225.03081969993  lat=-0.0014099728228357592
+ wat=0.0008430629426284694  pat=-2.2704179481670327e-10  ua=-9.299955530213071e-10
+ lua=-1.895419662571017e-17  wua=5.533408517693326e-16  pua=-4.048631130193895e-23
+ ub=1.7452953656338776e-18  lub=1.6993303903817467e-25  wub=-1.5523341968279492e-25
+ pub=-8.842959111539231e-32  kvth0=2.200000022436374e-09  lkvth0=-1e-08
+ wkvth0=2.2e-06  pkvth0=-5.000000000000006e-14  pdiblc2=0.0014631589283460582
+ lpdiblc2=4.3321462809641336e-11  wpdiblc2=5.538437869859112e-10  ppdiblc2=-1.6836522568414015e-16
+ nfactor=0.7519367770474076  lnfactor=3.441792864021663e-08  wnfactor=5.686789518941879e-07
+ pnfactor=-4.5698535883716307e-14  width=1.126e-05  lwidth=0.0
+ wwidth=-1.2336900000000002e-11  pwidth=0.0  cit=0.0005083528868770419
+ lcit=3.1587154178780196e-11  wcit=-5.535650859079283e-11  pcit=-7.444721942163402e-17
+ length=6.8e-07  llength=-9e-14  wlength=0.0
+ plength=0.0  u0=0.02938225829142401  lu0=1.0835575289868594e-09
+ wu0=5.358324060845336e-09  pu0=-1.2718110217772721e-15  tvoff=0.0012939926565811435
+ ltvoff=7.801333472846237e-11  wtvoff=4.785625808270685e-10  ptvoff=-4.8110332301946186e-17
+ ags=0.2618620011915838  lags=8.805903113006035e-08  wags=1.1232198416452896e-06
+ pags=-1.6913528769794303e-13  ute=-1.2689821957275833  lute=3.7234065437774795e-09
+ wute=1.939012786914633e-08  pute=-1.2298892186705685e-14  ku0=-3.19999999428514e-08
+ lku0=2e-07  wku0=7.000000000000001e-07  pku0=-5.0000000000000014e-14
+ voff=-0.14354439148921347  lvoff=2.1589292377459246e-09  wvoff=3.5639359149356872e-09
+ pvoff=-1.6578929351540563e-15  eta0=0.28083662208913346  leta0=7.428607240696133e-10
+ weta0=6.706715509856895e-08  peta0=-7.443286987532188e-15  kt1=-0.2539618392394354
+ lkt1=-5.4078716413902765e-09  wkt1=-3.4392753753382353e-09  pkt1=3.0385021540819158e-15
+ kt2=-0.05522459422927911  lkt2=-1.0603904559303549e-11  wkt2=1.641721363966448e-09
+ pkt2=-1.341244562936207e-16  kvth0we=0.0035012269741637072  lkvth0we=-1.4453371684037646e-10
+ wkvth0we=-1.3496700049484528e-11  pkvth0we=1.6870838902725364e-17  vth0=0.4572404269032315
+ lvth0=-2.7243710583771336e-09  wvth0=4.025751035275272e-09  pvth0=1.0007883167887145e-16
+ a0=0.2941045581631747  la0=5.572445099710581e-08  wa0=6.085146853546078e-07
+ pa0=-4.0022089836596455e-14  keta=-0.09792103712313566  lketa=5.0754896117098695e-09
+ wketa=8.73105519130061e-09  pketa=-2.398110385750143e-16  uc1=-3.186750280062144e-11
+ luc1=1.3472345489486857e-17  wuc1=6.744950814846751e-17  puc1=-1.8641835598545402e-23
+ ub1=-3.45131703496804e-18  lub1=-8.875343959893466e-26  wub1=-1.8500236762993489e-25
+ pub1=1.379996674820019e-31  ua1=2.710759375217507e-09  lua1=7.89520786409623e-17
+ wua1=1.3164612829496616e-16  pua1=-1.235064345146337e-22  pclm=0.6397689018011363
+ lpclm=7.160546757045446e-09  wpclm=5.3729896525227275e-08  ppclm=-2.060490803647839e-14
+ k2=0.040703446714231185  lk2=2.2983213014861478e-10  wk2=-4.165501550691858e-09
+ pk2=8.881060587109556e-16  vsat=62204.72634702591  lvsat=0.00045544904315465283
+ wvsat=0.009709108075658114  pvsat=-4.5464108683022026e-10  uc=8.16067086633878e-11
+ luc=1.6328912821999285e-17  wuc=4.987345390106423e-17  puc=-9.01684623082474e-24
+ lmin=1.8e-07  lmax=5e-007  wmin=1.23e-006
+ wmax=1.003e-005

    9:  type=n
+ drout=0.5  saref=1e-05  pbsws=0.32
+ llc=0.0  pdiblcb=0.0  xw=0.0
+ cdsc=0.0  clc=1e-07  minv=-0.34
+ pbswgd=0.952  cdscb=0.0  toxe=3.981e-09
+ cjd=1e-10  cjswgs=3.82e-10  binunit=2.0
+ jtsswgs=1.09e-09  cigsd=3.925e-20  wlodku0=1.0
+ tpbsw=0.000894  rsw=90.88  njd=1.0
+ w0=0.0  pdiblc1=0.0  dwb=0.0
+ igbmod=0.0  dmdg=0.0  delta=0.005
+ wlodvth=1.0  etab=-0.308  permod=1.0
+ tnjtsswg=1.08  dlcig=2.5e-09  rshg=8.23
+ xgl=-3.1e-08  acde=0.4  capmod=2.0
+ noia=1.25e+42  tcjswg=0.00088  cgdo=1e-10
+ rbdb=50.0  cigbinv=0.006  jswgs=6.9e-13
+ wlod=5e-07  xrcrg2=1.0  jsd=2.85e-07
+ prt=0.0  minr=0.001  dmci=3.15e-07
+ ww=0.0  cigbacc=0.2809  wlc=0.0
+ dwj=0.0  dvt1w=0.0  mjswgd=0.541
+ aigbacc=0.01213  beta0=17.8  a1=0.0
+ alpha0=1.454e-07  dvt0=0.09708  lln=1.0
+ aigc=0.01  trnqsmod=0.0  cjs=1e-10
+ lodeta0=2.0  cf=1.0  ijthsfwd=0.01
+ ckappad=0.6  rbsb=50.0  xtsswgd=0.2886
+ ud=0.0  epsrox=3.9  rbpd=50.0
+ tempmod=0.0  alpha1=2.295  pbd=0.6882682
+ xtid=3.0  acnqsmod=0.0  nigbacc=4.05
+ rgatemod=0.0  cgbo=0.0  rsh=7.28
+ jtsswgd=1.09e-09  ngate=9e+19  tcjsw=0.000809
+ poxedge=1.0  xtsswgs=0.2886  mjswd=0.202
+ xrcrg1=12.0  pditsl=0.0  noff=1.973
+ lpeb=2.178e-08  ckappas=0.6  noib=7e+23
+ dmcgt=0.0  dsub=0.633  ll=0.0
+ cgso=1e-10  vtsswgs=10.0  jss=2.85e-07
+ ntox=1.0  dvtp1=0.0  mobmod=0.0
+ njs=1.0  cigc=1.515e-05  cjswd=1.185e-10
+ voffcv=-0.0904  mjsws=0.202  nigbinv=1.0
+ xl=-1.5e-08  ef=0.904  wl=0.0
+ rbodymod=0.0  lwc=0.0  wr=1.0
+ jswd=6.9e-13  pbs=0.6882682  dvt2w=0.0
+ wln=1.0  cdscd=0.0  ijthdrev=0.01
+ dvt0w=0.0  jsws=6.9e-13  nigc=1.0
+ b1=0.0  lint=2.595e-08  rbpb=50.0
+ noic=60800000.0  egidl=0.2624  wwc=0.0
+ dlc=2.595e-08  pbswgs=0.952  vtsswgd=10.0
+ fprout=0.0  lwn=1.0  lwl=0.0
+ ku0we=0.0  rgeomod=1.0  rbps=50.0
+ stk2=2.5e-09  k3=-3.7  dwg=0.0
+ bigc=0.00144  llodku0=1.0  bigbinv=0.03
+ tku0=0.03  xtis=3.0  steta0=-1.1e-10
+ wec=0.0  pscbe2=1e-20  pigcd=2.171
+ dvt1=0.3053  em=30000000.0  ijthdfwd=0.01
+ lodk2=1.0  xj=1.6e-07  ijthsrev=0.01
+ cle=0.6  aigbinv=0.35  njtsswg=11.6
+ tnom=25.0  ndep=5.8e+17  mjs=0.359
+ cgidl=0.25  eigbinv=1.1  xjbvd=1.0
+ phin=0.0  prwg=0.0  nsd=1e+20
+ toxref=3e-09  wwlc=0.0  mjswgs=0.541
+ lw=0.0  bigbacc=0.006537  agidl=2.593e-09
+ wpemod=1.0  dwc=0.0  cgdl=1e-10
+ tpbswg=0.00133  wint=1.02e-08  jswgd=6.9e-13
+ xgw=0.0  a2=0.995  dvtp0=1.46e-06
+ lpe0=9.921e-09  kt1l=0.0  k1=0.448
+ gbmin=1e-12  dmcg=2.05e-07  paramchk=1.0
+ kvsat=0.4  tpb=0.00149  voffl=-1.22e-09
+ xpart=1.0  pbswd=0.32  pscbe1=450000000.0
+ wwl=0.0  cjswgd=3.82e-10  ngcon=1.0
+ mjd=0.359  dvt2=-0.6939  llodvth=1.0
+ pvag=0.6279  k2we=0.0038  diomod=1.0
+ sbref=1e-05  rdsw=200.0  tcj=0.000905
+ rdsmod=1.0  aigsd=0.008379  bvs=11.25
+ dtox=5.958e-10  bgidl=1850800000.0  prwb=0.0
+ wwn=1.0  cgsl=1e-10  moin=5.346
+ bvd=11.25  version=4.5  pditsd=0.0
+ scref=1e-06  bigsd=0.0002699  rdw=90.88
+ igcmod=0.0  b0=0.0  lwlc=0.0
+ fnoimod=1.0  toxm=3.981e-09  pdits=0.0
+ web=0.0  xjbvs=1.0  k3b=1.2
+ cjsws=1.185e-10  at=104976.91547142857  lat=0.0002973248571428496
+ wat=0.022813572309142882  pat=1.986826457141438e-10  ua=-2.8727601300357157e-10
+ lua=-4.125569928569742e-18  wua=-2.0270978038810713e-16  pua=1.5760186621423404e-24
+ ub=1.7181257064000003e-18  lub=2.8715362857117166e-27  wub=-1.0508912542450021e-25
+ pub=-6.179485814260529e-34  kvth0=2.200000907941728e-09  lkvth0=-1.0000000000010082e-08
+ wkvth0=2.1999999999999993e-06  pkvth0=-4.999999999998994e-14  pdiblc2=0.001078379253439286
+ lpdiblc2=-4.1121959285726006e-12  wpdiblc2=-9.551355683532154e-11  ppdiblc2=-1.3877899078563772e-18
+ nfactor=1.3084614274324993  lnfactor=-1.1502157928510005e-09  wnfactor=1.1434716940077544e-07
+ pnfactor=2.511115570210508e-15  width=1.76e-06  lwidth=-0.0
+ wwidth=-6.519000000000001e-13  pwidth=-0.0  cit=0.0011626392641535719
+ lcit=7.918171214280867e-12  wcit=-1.5382050550889309e-10  pcit=-2.923415593568258e-18
+ length=3e-05  llength=-2.0000000000000003e-10  wlength=2.0678696850089702e-27
+ plength=-2.06786968500897e-32  u0=0.037747688152553575  lu0=-3.596376535714965e-11
+ wu0=-4.0856582780408954e-09  pu0=2.0884239389283107e-17  tvoff=0.0014972655205607143
+ ltvoff=-1.6031969285720439e-12  wtvoff=3.3642189778212584e-12  ptvoff=1.955746872144168e-18
+ ags=0.4933623499999999  lags=-4.3448228571417095e-09  wags=-3.6150106082499874e-08
+ pags=5.445967642843404e-16  ute=-1.6354862600214288  lute=-3.196599571424803e-09
+ wute=7.821032532135734e-08  pute=5.483775728545652e-16  ku0=-3.2000000115044745e-08
+ lku0=2.0000000000000354e-07  wku0=7.000000000000001e-07  pku0=-5.000000000000235e-14
+ voff=-0.12477471127728565  lvoff=7.363668857096606e-11  wvoff=-1.258481403353862e-08
+ pvoff=-1.032903494256776e-17  eta0=0.38924622357464295  leta0=-2.1542863571578318e-10
+ weta0=-9.762477429356078e-08  peta0=2.5696815692947765e-16  kt1=-0.21738791100357133
+ lkt1=2.338143571419578e-10  wkt1=-3.6117008046072158e-09  pkt1=9.401120715041683e-18
+ kt2=-0.054974972284957166  lkt2=3.148984857406381e-12  wkt2=-3.420485994769941e-11
+ pkt2=-3.3664424744795197e-18  kvth0we=0.003492791560442857  lkvth0we=1.0249054285777384e-12
+ wkvth0we=-1.1251035699714325e-11  pkvth0we=-1.0717657714545764e-19  vth0=0.45069854369039286
+ lvth0=-5.4016664999759606e-11  wvth0=2.727593643291794e-09  pvth0=3.025984844997577e-17
+ a0=1.2355039478178578  la0=2.020666499994027e-09  wa0=-1.327865876684646e-07
+ pa0=4.911372550029899e-16  keta=-0.028997227840460712  lketa=2.8575080921424057e-10
+ wketa=-9.489290451233325e-09  pketa=-7.296219533354165e-17  uc1=-1.6625566987142888e-11
+ luc1=-7.320355428569012e-19  wuc1=-1.7369422638314266e-17  puc1=1.5617706771413163e-25
+ ub1=-4.6694004508464296e-18  lub1=-8.587268785708307e-27  wub1=4.798466522961078e-25
+ pub1=4.50985550642115e-33  ua1=2.7149577890178585e-09  lua1=-2.933123214302097e-18
+ wua1=-1.8655966107196551e-16  pua1=-3.7770684641353995e-25  pclm=0.6643127907289286
+ lpclm=9.281135714538685e-12  wpclm=7.74541341778507e-12  ppclm=-2.5199969285855894e-18
+ k2=0.04957639782370715  lk2=6.838081157135657e-11  wk2=-4.305259496664793e-09
+ pk2=-2.6053728132828717e-17  vsat=55665.559685714295  lvsat=-0.00011317485714278879
+ wvsat=0.017337656569571425  pvsat=1.242996142857143e-10  uc=5.88784380817857e-11
+ luc=-2.8835863571399327e-19  wuc=1.1385803902403583e-17  puc=8.872061928373563e-27
+ lmin=1e-005  lmax=2e-05  wmin=5.3e-007
+ wmax=1.23e-006

    10:  type=n
+ drout=0.5  saref=1e-05  pbsws=0.32
+ llc=0.0  pdiblcb=0.0  xw=0.0
+ cdsc=0.0  clc=1e-07  minv=-0.34
+ pbswgd=0.952  cdscb=0.0  toxe=3.981e-09
+ cjd=1e-10  cjswgs=3.82e-10  binunit=2.0
+ jtsswgs=1.09e-09  cigsd=3.925e-20  wlodku0=1.0
+ tpbsw=0.000894  rsw=90.88  njd=1.0
+ w0=0.0  pdiblc1=0.0  dwb=0.0
+ igbmod=0.0  dmdg=0.0  delta=0.005
+ wlodvth=1.0  etab=-0.308  permod=1.0
+ tnjtsswg=1.08  dlcig=2.5e-09  rshg=8.23
+ xgl=-3.1e-08  acde=0.4  capmod=2.0
+ noia=1.25e+42  tcjswg=0.00088  cgdo=1e-10
+ rbdb=50.0  cigbinv=0.006  jswgs=6.9e-13
+ wlod=5e-07  xrcrg2=1.0  jsd=2.85e-07
+ prt=0.0  minr=0.001  dmci=3.15e-07
+ ww=0.0  cigbacc=0.2809  wlc=0.0
+ dwj=0.0  dvt1w=0.0  mjswgd=0.541
+ aigbacc=0.01213  beta0=17.8  a1=0.0
+ alpha0=1.454e-07  dvt0=0.09708  lln=1.0
+ aigc=0.01  trnqsmod=0.0  cjs=1e-10
+ lodeta0=2.0  cf=1.0  ijthsfwd=0.01
+ ckappad=0.6  rbsb=50.0  xtsswgd=0.2886
+ ud=0.0  epsrox=3.9  rbpd=50.0
+ tempmod=0.0  alpha1=2.295  pbd=0.6882682
+ xtid=3.0  acnqsmod=0.0  nigbacc=4.05
+ rgatemod=0.0  cgbo=0.0  rsh=7.28
+ jtsswgd=1.09e-09  ngate=9e+19  tcjsw=0.000809
+ poxedge=1.0  xtsswgs=0.2886  mjswd=0.202
+ xrcrg1=12.0  pditsl=0.0  noff=1.973
+ lpeb=2.178e-08  ckappas=0.6  noib=7e+23
+ dmcgt=0.0  dsub=0.633  ll=0.0
+ cgso=1e-10  vtsswgs=10.0  jss=2.85e-07
+ ntox=1.0  dvtp1=0.0  mobmod=0.0
+ njs=1.0  cigc=1.515e-05  cjswd=1.185e-10
+ voffcv=-0.0904  mjsws=0.202  nigbinv=1.0
+ xl=-1.5e-08  ef=0.904  wl=0.0
+ rbodymod=0.0  lwc=0.0  wr=1.0
+ jswd=6.9e-13  pbs=0.6882682  dvt2w=0.0
+ wln=1.0  cdscd=0.0  ijthdrev=0.01
+ dvt0w=0.0  jsws=6.9e-13  nigc=1.0
+ b1=0.0  lint=2.595e-08  rbpb=50.0
+ noic=60800000.0  egidl=0.2624  wwc=0.0
+ dlc=2.595e-08  pbswgs=0.952  vtsswgd=10.0
+ fprout=0.0  lwn=1.0  lwl=0.0
+ ku0we=0.0  rgeomod=1.0  rbps=50.0
+ stk2=2.5e-09  k3=-3.7  dwg=0.0
+ bigc=0.00144  llodku0=1.0  bigbinv=0.03
+ tku0=0.03  xtis=3.0  steta0=-1.1e-10
+ wec=0.0  pscbe2=1e-20  pigcd=2.171
+ dvt1=0.3053  em=30000000.0  ijthdfwd=0.01
+ lodk2=1.0  xj=1.6e-07  ijthsrev=0.01
+ cle=0.6  aigbinv=0.35  njtsswg=11.6
+ tnom=25.0  ndep=5.8e+17  mjs=0.359
+ cgidl=0.25  eigbinv=1.1  xjbvd=1.0
+ phin=0.0  prwg=0.0  nsd=1e+20
+ toxref=3e-09  wwlc=0.0  mjswgs=0.541
+ lw=0.0  bigbacc=0.006537  agidl=2.593e-09
+ wpemod=1.0  dwc=0.0  cgdl=1e-10
+ tpbswg=0.00133  wint=1.02e-08  jswgd=6.9e-13
+ xgw=0.0  a2=0.995  dvtp0=1.46e-06
+ lpe0=9.921e-09  kt1l=0.0  k1=0.448
+ gbmin=1e-12  dmcg=2.05e-07  paramchk=1.0
+ kvsat=0.4  tpb=0.00149  voffl=-1.22e-09
+ xpart=1.0  pbswd=0.32  pscbe1=450000000.0
+ wwl=0.0  cjswgd=3.82e-10  ngcon=1.0
+ mjd=0.359  dvt2=-0.6939  llodvth=1.0
+ pvag=0.6279  k2we=0.0038  diomod=1.0
+ sbref=1e-05  rdsw=200.0  tcj=0.000905
+ rdsmod=1.0  aigsd=0.008379  bvs=11.25
+ dtox=5.958e-10  bgidl=1850800000.0  prwb=0.0
+ wwn=1.0  cgsl=1e-10  moin=5.346
+ bvd=11.25  version=4.5  pditsd=0.0
+ scref=1e-06  bigsd=0.0002699  rdw=90.88
+ igcmod=0.0  b0=0.0  lwlc=0.0
+ fnoimod=1.0  toxm=3.981e-09  pdits=0.0
+ web=0.0  xjbvs=1.0  k3b=1.2
+ cjsws=1.185e-10  at=109466.39145535714  lat=-0.044597434982142845
+ wat=0.025854199188490273  pat=-3.020758614775976e-08  ua=-3.5285515089813313e-10
+ lua=6.516658090170452e-16  wua=-1.7757299566802358e-16  pua=-2.4979182853869305e-22
+ ub=1.7630937518400973e-18  lub=-4.468089181152599e-25  wub=-1.1387939330309254e-25
+ pub=8.728473020449692e-32  kvth0=2.1999997035253575e-09  lkvth0=-9.999999999999484e-09
+ wkvth0=2.2000000000000005e-06  pkvth0=-5.000000000000048e-14  pdiblc2=0.0010152906497881496
+ lpdiblc2=6.267738405827922e-10  wpdiblc2=-1.1710292547578735e-10  ppdiblc2=2.145058964968018e-16
+ nfactor=1.2904648429399348  lnfactor=1.7881562913279251e-07  wnfactor=1.5311519703387995e-07
+ pnfactor=-3.851691607608345e-13  width=1.76e-06  lwidth=0.0
+ wwidth=-6.519000000000001e-13  pwidth=0.0  cit=0.0012850802677922078
+ lcit=-1.216491865172078e-09  wcit=-1.991697355091314e-10  pcit=4.50568884408815e-16
+ length=1.1200000000000001e-05  llength=-1.2e-11  wlength=0.0
+ plength=0.0  u0=0.03717230761181007  lu0=5.717841642077913e-09
+ wu0=-3.747427473350247e-09  pu0=-3.3614238075171997e-15  tvoff=0.001472935858099026
+ ltvoff=2.416934276883119e-10  wtvoff=3.389981272115258e-11  ptvoff=-3.03400190561169e-16
+ ags=0.4261437980827922  lags=6.678406963149351e-07  wags=-2.7083936938141246e-08
+ pags=-9.011709467930194e-14  ute=-1.6850048238855517  lute=4.919890390698051e-07
+ wute=8.683148473718338e-08  pute=-8.566321658540575e-14  ku0=-3.199999977798069e-08
+ lku0=1.9999999999999965e-07  wku0=6.999999999999999e-07  pku0=-4.999999999999978e-14
+ voff=-0.12360828595198861  lvoff=-1.159061656439934e-08  wvoff=-1.27689831881165e-08
+ pvoff=1.831362510836219e-15  eta0=0.38578838922275965  leta0=3.4362914883116975e-08
+ weta0=-9.345271705518761e-08  peta0=-4.1463604226802024e-14  kt1=-0.21385629590280034
+ lkt1=-3.508233665056816e-08  wkt1=-3.418839532311279e-09  pkt1=-1.9192116022443274e-15
+ kt2=-0.0549216254314448  lkt2=-5.303195502662327e-10  wkt2=-8.912148036834908e-11
+ pkt2=5.457997617320171e-16  kvth0we=0.0035081441755032477  lkvth0we=-1.525012451753258e-10
+ wkvth0we=-1.2862432138880254e-11  pkvth0we=1.6006787814513838e-17  vth0=0.4498399099841721
+ lvth0=8.532320397207802e-09  wvth0=3.2197748011160807e-09  pvth0=-4.8915517297928886e-15
+ a0=1.2661909958003246  la0=-3.048498133246749e-07  wa0=-1.2460550386564935e-07
+ pa0=-8.131970077314954e-14  keta=-0.024646578131006496  lketa=-4.3220746285327924e-08
+ wketa=-1.0596451150737015e-08  pketa=1.0998644799703342e-14  uc1=-2.814272284894481e-11
+ luc1=1.1443952307516234e-16  wuc1=-1.4758629570059247e-17  puc1=-2.5951753614836047e-23
+ ub1=-4.802753910491072e-18  lub1=1.3249473276607143e-24  wub1=5.5092952983867675e-25
+ pub1=-7.0631891991926895e-31  ua1=2.669286963125e-09  lua1=4.537751357142858e-16
+ wua1=-1.9245003224034059e-16  pua1=5.852600483733727e-23  pclm=0.6641272078551137
+ lpclm=1.8651098738635514e-09  wpclm=3.7054329360787094e-10  ppclm=-3.630498798829444e-15
+ k2=0.050631605723461856  lk2=-1.0483698185975662e-08  wk2=-4.710824093948991e-09
+ pk2=4.029592244709153e-15  vsat=53904.59448769076  lvsat=0.017496477123092512
+ wvsat=0.019270686675623334  pvsat=-1.9206001446233355e-08  uc=5.452804998327924e-11
+ luc=4.321552234935063e-17  wuc=1.1528547351305182e-17  puc=-1.4185624270876372e-24
+ lmin=1.2e-006  lmax=1e-005  wmin=5.3e-007
+ wmax=1.23e-006

    11:  type=n
+ drout=0.5  saref=1e-05  pbsws=0.32
+ llc=0.0  pdiblcb=0.0  xw=0.0
+ cdsc=0.0  clc=1e-07  minv=-0.34
+ pbswgd=0.952  cdscb=0.0  toxe=3.981e-09
+ cjd=1e-10  cjswgs=3.82e-10  binunit=2.0
+ jtsswgs=1.09e-09  cigsd=3.925e-20  wlodku0=1.0
+ tpbsw=0.000894  rsw=90.88  njd=1.0
+ w0=0.0  pdiblc1=0.0  dwb=0.0
+ igbmod=0.0  dmdg=0.0  delta=0.005
+ wlodvth=1.0  permod=1.0  tnjtsswg=1.08
+ dlcig=2.5e-09  rshg=8.23  xgl=-3.1e-08
+ acde=0.4  capmod=2.0  noia=1.25e+42
+ tcjswg=0.00088  cgdo=1e-10  rbdb=50.0
+ cigbinv=0.006  jswgs=6.9e-13  wlod=5e-07
+ xrcrg2=1.0  jsd=2.85e-07  prt=0.0
+ minr=0.001  dmci=3.15e-07  ww=0.0
+ cigbacc=0.2809  wlc=0.0  dwj=0.0
+ dvt1w=0.0  mjswgd=0.541  aigbacc=0.01213
+ beta0=17.8  a1=0.0  alpha0=1.454e-07
+ dvt0=0.09708  lln=1.0  aigc=0.01
+ trnqsmod=0.0  cjs=1e-10  lodeta0=2.0
+ cf=1.0  ijthsfwd=0.01  ckappad=0.6
+ rbsb=50.0  xtsswgd=0.2886  ud=0.0
+ epsrox=3.9  rbpd=50.0  tempmod=0.0
+ alpha1=2.295  pbd=0.6882682  xtid=3.0
+ acnqsmod=0.0  nigbacc=4.05  rgatemod=0.0
+ cgbo=0.0  rsh=7.28  jtsswgd=1.09e-09
+ ngate=9e+19  tcjsw=0.000809  poxedge=1.0
+ xtsswgs=0.2886  mjswd=0.202  xrcrg1=12.0
+ pditsl=0.0  noff=1.973  lpeb=2.178e-08
+ ckappas=0.6  noib=7e+23  dmcgt=0.0
+ dsub=0.633  ll=0.0  cgso=1e-10
+ vtsswgs=10.0  jss=2.85e-07  ntox=1.0
+ dvtp1=0.0  mobmod=0.0  njs=1.0
+ cigc=1.515e-05  cjswd=1.185e-10  voffcv=-0.0904
+ mjsws=0.202  nigbinv=1.0  xl=-1.5e-08
+ ef=0.904  wl=0.0  rbodymod=0.0
+ lwc=0.0  wr=1.0  jswd=6.9e-13
+ pbs=0.6882682  dvt2w=0.0  wln=1.0
+ cdscd=0.0  ijthdrev=0.01  dvt0w=0.0
+ jsws=6.9e-13  nigc=1.0  b1=0.0
+ lint=2.595e-08  rbpb=50.0  noic=60800000.0
+ egidl=0.2624  wwc=0.0  dlc=2.595e-08
+ pbswgs=0.952  vtsswgd=10.0  fprout=0.0
+ lwn=1.0  lwl=0.0  ku0we=0.0
+ rgeomod=1.0  rbps=50.0  stk2=2.5e-09
+ k3=-3.7  dwg=0.0  bigc=0.00144
+ llodku0=1.0  bigbinv=0.03  tku0=0.03
+ xtis=3.0  steta0=-1.1e-10  wec=0.0
+ pscbe2=1e-20  pigcd=2.171  dvt1=0.3053
+ em=30000000.0  ijthdfwd=0.01  lodk2=1.0
+ xj=1.6e-07  ijthsrev=0.01  cle=0.6
+ aigbinv=0.35  njtsswg=11.6  tnom=25.0
+ ndep=5.8e+17  mjs=0.359  cgidl=0.25
+ eigbinv=1.1  xjbvd=1.0  phin=0.0
+ prwg=0.0  nsd=1e+20  toxref=3e-09
+ wwlc=0.0  mjswgs=0.541  lw=0.0
+ bigbacc=0.006537  agidl=2.593e-09  wpemod=1.0
+ dwc=0.0  cgdl=1e-10  tpbswg=0.00133
+ wint=1.02e-08  jswgd=6.9e-13  xgw=0.0
+ a2=0.995  dvtp0=1.46e-06  lpe0=9.921e-09
+ kt1l=0.0  k1=0.448  gbmin=1e-12
+ dmcg=2.05e-07  paramchk=1.0  kvsat=0.4
+ tpb=0.00149  voffl=-1.22e-09  xpart=1.0
+ pbswd=0.32  pscbe1=450000000.0  wwl=0.0
+ cjswgd=3.82e-10  ngcon=1.0  mjd=0.359
+ dvt2=-0.6939  llodvth=1.0  pvag=0.6279
+ k2we=0.0038  diomod=1.0  sbref=1e-05
+ rdsw=200.0  tcj=0.000905  rdsmod=1.0
+ aigsd=0.008379  bvs=11.25  dtox=5.958e-10
+ bgidl=1850800000.0  prwb=0.0  wwn=1.0
+ cgsl=1e-10  moin=5.346  bvd=11.25
+ version=4.5  pditsd=0.0  scref=1e-06
+ bigsd=0.0002699  rdw=90.88  igcmod=0.0
+ b0=0.0  lwlc=0.0  fnoimod=1.0
+ toxm=3.981e-09  pdits=0.0  web=0.0
+ xjbvs=1.0  k3b=1.2  cjsws=1.185e-10
+ at=100709.3124277551  lat=-0.034088940149020405  wat=0.008908095113825504
+ pat=-9.87226125816204e-09  ua=6.953630739489795e-10  lua=-6.061960607994898e-16
+ wua=-6.02536393242959e-16  pua=2.6016424855122946e-22  ub=1.240796079193877e-18
+ lub=1.7994828906020442e-25  wub=-2.589607777656118e-25  pub=2.6138239155952005e-31
+ etab=-0.3079541233367347  letab=-5.5051995918353954e-11  wetab=-5.642829581631281e-11
+ petab=6.771395497957537e-17  kvth0=2.2000001395840523e-09  lkvth0=-1.0000000000000144e-08
+ wkvth0=2.2e-06  pkvth0=-4.9999999999999976e-14  pdiblc2=0.001398667381622449
+ lpdiblc2=1.667217623816327e-10  wpdiblc2=1.107796933651019e-10  ppdiblc2=-5.89532461122653e-17
+ nfactor=1.5001901366479597  lnfactor=-7.285472331683728e-08  wnfactor=-1.5977344305198999e-07
+ pnfactor=-9.702792657790618e-15  width=1.76e-06  lwidth=0.0
+ wwidth=-6.519000000000001e-13  pwidth=0.0  cit=0.00023360544460952214
+ lcit=4.527792264714483e-11  wcit=2.3080091962350216e-10  pcit=-6.539590175034536e-17
+ length=1.7e-06  llength=-6.000000000000001e-13  wlength=0.0
+ plength=0.0  u0=0.04742408954249999  lu0=-6.584296674750001e-09
+ wu0=-1.0859174621953566e-08  pu0=5.172672770806785e-15  tvoff=0.0015596770296479594
+ ltvoff=1.3760402182959178e-10  wtvoff=-3.102841983384185e-10  ptvoff=1.096206227103163e-16
+ ags=1.0063499339744897  lags=-2.8406666755102017e-08  wags=-2.864074026671938e-07
+ pags=2.2107106419556114e-13  ute=-1.2387470441724489  lute=-4.352029658591849e-08
+ wute=-2.6252490416816344e-08  pute=5.0037553599393914e-14  ku0=-3.200000001468566e-08
+ lku0=2.0000000000000002e-07  wku0=6.999999999999999e-07  pku0=-4.999999999999989e-14
+ voff=-0.14124143510765302  lvoff=9.56916242239793e-09  wvoff=-4.406553350622472e-09
+ pvoff=-8.203553294156614e-15  eta0=0.4508352795793368  leta0=-4.369335354477551e-08
+ weta0=-1.8543503492711992e-07  peta0=6.891517721951674e-14  kt1=-0.221172247680102
+ lkt1=-2.6303194517806153e-08  wkt1=-1.8394759766331638e-08  pkt1=1.6051892678580103e-14
+ kt2=-0.056689404672806115  lkt2=1.5910155393673476e-09  wkt2=1.1732160755158164e-09
+ pkt2=-9.690053053289814e-16  kvth0we=0.003500407414336734  lkvth0we=-1.4321713177550967e-10
+ wkvth0we=-1.2050356134183153e-11  pkvth0we=1.5032296608877315e-17  vth0=0.46342424410765304
+ lvth0=-7.768880550969384e-09  wvth0=-7.917822018484725e-09  pvth0=8.473564453728077e-15
+ a0=1.1588501456938778  la0=-1.7604079319693894e-07  wa0=-3.547632461141839e-07
+ pa0=1.9486958992509193e-13  keta=-0.04241465139545918  lketa=-2.18990583679847e-08
+ wketa=-6.9786856153709264e-09  pketa=6.657326157264037e-15  uc1=1.2394343300178573e-10
+ luc1=-6.806386394571427e-17  wuc1=-9.030119951630356e-17  puc1=6.469933032065712e-23
+ ub1=-3.512550829132654e-18  lub1=-2.2329636996938683e-25  wub1=-4.197836507811215e-25
+ pub1=4.58536896824489e-31  ua1=3.1540629221224486e-09  lua1=-1.279560150826529e-16
+ wua1=-1.3799419631061219e-16  pua1=-6.82099827833681e-24  pclm=0.7543179591020406
+ lpclm=-1.063637916224488e-07  wpclm=-1.1233307577051008e-07  ppclm=1.316138440781121e-13
+ k2=0.04236914991841836  lk2=-5.687512199234662e-10  wk2=-5.52288573440297e-10
+ pk2=-9.606503799012812e-16  vsat=72001.38864096937  lvsat=-0.004219675860841834
+ wvsat=-0.00029506672517806096  pvsat=4.272902634728317e-09  uc=6.298110902448979e-11
+ luc=3.307185149989795e-17  wuc=8.049834958091852e-18  puc=2.7558924447683612e-24
+ lmin=5e-007  lmax=1.2e-006  wmin=5.3e-007
+ wmax=1.23e-006

    12:  type=n
+ drout=0.5  saref=1e-05  pbsws=0.32
+ llc=0.0  pdiblcb=0.0  xw=0.0
+ cdsc=0.0  clc=1e-07  minv=-0.34
+ pbswgd=0.952  cdscb=0.0  toxe=3.981e-09
+ cjd=1e-10  cjswgs=3.82e-10  binunit=2.0
+ jtsswgs=1.09e-09  cigsd=3.925e-20  wlodku0=1.0
+ tpbsw=0.000894  rsw=90.88  njd=1.0
+ w0=0.0  pdiblc1=0.0  dwb=0.0
+ igbmod=0.0  dmdg=0.0  delta=0.005
+ wlodvth=1.0  permod=1.0  tnjtsswg=1.08
+ dlcig=2.5e-09  rshg=8.23  xgl=-3.1e-08
+ acde=0.4  capmod=2.0  noia=1.25e+42
+ tcjswg=0.00088  cgdo=1e-10  rbdb=50.0
+ cigbinv=0.006  jswgs=6.9e-13  wlod=5e-07
+ xrcrg2=1.0  jsd=2.85e-07  prt=0.0
+ minr=0.001  dmci=3.15e-07  ww=0.0
+ cigbacc=0.2809  wlc=0.0  dwj=0.0
+ dvt1w=0.0  mjswgd=0.541  aigbacc=0.01213
+ beta0=17.8  a1=0.0  alpha0=1.454e-07
+ dvt0=0.09708  lln=1.0  aigc=0.01
+ trnqsmod=0.0  cjs=1e-10  lodeta0=2.0
+ cf=1.0  ijthsfwd=0.01  ckappad=0.6
+ rbsb=50.0  xtsswgd=0.2886  ud=0.0
+ epsrox=3.9  rbpd=50.0  tempmod=0.0
+ alpha1=2.295  pbd=0.6882682  xtid=3.0
+ acnqsmod=0.0  nigbacc=4.05  rgatemod=0.0
+ cgbo=0.0  rsh=7.28  jtsswgd=1.09e-09
+ ngate=9e+19  tcjsw=0.000809  poxedge=1.0
+ xtsswgs=0.2886  mjswd=0.202  xrcrg1=12.0
+ pditsl=0.0  noff=1.973  lpeb=2.178e-08
+ ckappas=0.6  noib=7e+23  dmcgt=0.0
+ dsub=0.633  ll=0.0  cgso=1e-10
+ vtsswgs=10.0  jss=2.85e-07  ntox=1.0
+ dvtp1=0.0  mobmod=0.0  njs=1.0
+ cigc=1.515e-05  cjswd=1.185e-10  voffcv=-0.0904
+ mjsws=0.202  nigbinv=1.0  xl=-1.5e-08
+ ef=0.904  wl=0.0  rbodymod=0.0
+ lwc=0.0  wr=1.0  jswd=6.9e-13
+ pbs=0.6882682  dvt2w=0.0  wln=1.0
+ cdscd=0.0  ijthdrev=0.01  dvt0w=0.0
+ jsws=6.9e-13  nigc=1.0  b1=0.0
+ lint=2.595e-08  rbpb=50.0  noic=60800000.0
+ egidl=0.2624  wwc=0.0  dlc=2.595e-08
+ pbswgs=0.952  vtsswgd=10.0  fprout=0.0
+ lwn=1.0  lwl=0.0  ku0we=0.0
+ rgeomod=1.0  rbps=50.0  stk2=2.5e-09
+ k3=-3.7  dwg=0.0  bigc=0.00144
+ llodku0=1.0  bigbinv=0.03  tku0=0.03
+ xtis=3.0  steta0=-1.1e-10  wec=0.0
+ pscbe2=1e-20  pigcd=2.171  dvt1=0.3053
+ em=30000000.0  ijthdfwd=0.01  lodk2=1.0
+ xj=1.6e-07  ijthsrev=0.01  cle=0.6
+ aigbinv=0.35  njtsswg=11.6  tnom=25.0
+ ndep=5.8e+17  mjs=0.359  cgidl=0.25
+ eigbinv=1.1  xjbvd=1.0  phin=0.0
+ prwg=0.0  nsd=1e+20  toxref=3e-09
+ wwlc=0.0  mjswgs=0.541  lw=0.0
+ bigbacc=0.006537  agidl=2.593e-09  wpemod=1.0
+ dwc=0.0  cgdl=1e-10  tpbswg=0.00133
+ wint=1.02e-08  jswgd=6.9e-13  xgw=0.0
+ a2=0.995  dvtp0=1.46e-06  lpe0=9.921e-09
+ kt1l=0.0  k1=0.448  gbmin=1e-12
+ dmcg=2.05e-07  paramchk=1.0  kvsat=0.4
+ tpb=0.00149  voffl=-1.22e-09  xpart=1.0
+ pbswd=0.32  pscbe1=450000000.0  wwl=0.0
+ cjswgd=3.82e-10  ngcon=1.0  mjd=0.359
+ dvt2=-0.6939  llodvth=1.0  pvag=0.6279
+ k2we=0.0038  diomod=1.0  sbref=1e-05
+ rdsw=200.0  tcj=0.000905  rdsmod=1.0
+ aigsd=0.008379  bvs=11.25  dtox=5.958e-10
+ bgidl=1850800000.0  prwb=0.0  wwn=1.0
+ cgsl=1e-10  moin=5.346  bvd=11.25
+ version=4.5  pditsd=0.0  scref=1e-06
+ bigsd=0.0002699  rdw=90.88  igcmod=0.0
+ b0=0.0  lwlc=0.0  fnoimod=1.0
+ toxm=3.981e-09  pdits=0.0  web=0.0
+ xjbvs=1.0  k3b=1.2  cjsws=1.185e-10
+ at=37310.83983803572  lat=-0.0023897038541607143  wat=-0.012792482149924558
+ pat=9.780273737129917e-10  ua=-3.7127364545758955e-10  lua=-7.287770109620528e-17
+ wua=-1.3388709453404008e-16  pua=2.583959919677005e-23  ub=1.301172351607143e-18
+ lub=1.4976015285357145e-25  wub=3.9103788757008917e-25  pub=-6.361694110833036e-32
+ etab=-0.30885969115625  letab=3.97731913839289e-10  wetab=1.0574201221874892e-09
+ petab=-4.892102540223256e-16  kvth0=2.200000646859322e-09  lkvth0=-1.0000000000000215e-08
+ wkvth0=2.1999999999999993e-06  pkvth0=-4.999999999999976e-14  pdiblc2=0.0020180904475312505
+ lpdiblc2=-1.4298977057276788e-10  wpdiblc2=-1.2872198161187521e-10  ppdiblc2=6.079759137622323e-17
+ nfactor=1.360328756169642  lnfactor=-2.9240330776783637e-09  wnfactor=-1.7964318242616032e-07
+ pnfactor=2.3207702929454655e-16  width=1.76e-06  lwidth=0.0
+ wwidth=-6.519000000000001e-13  pwidth=0.0  cit=0.0004201999373869008
+ lcit=-4.801932374154452e-11  wcit=5.3071619282080617e-11  pcit=2.34687484203654e-17
+ length=6.8e-07  llength=-9e-14  wlength=0.0
+ plength=0.0  u0=0.03425454929575892  lu0=4.734486205386859e-13
+ wu0=-6.345938744866009e-10  pu0=6.038239707330265e-17  tvoff=0.0017198887348325895
+ ltvoff=5.749816923727678e-11  wtvoff=-4.528959542220998e-11  ptvoff=-2.2876678747787928e-17
+ ags=1.0046741722566963  lags=-2.75687858962054e-08  wags=2.095608712352008e-07
+ pags=-2.6913072755636108e-14  ute=-1.3102619816227679  lute=-7.762827860758952e-09
+ wute=7.016426452022325e-08  pute=1.8291761308741287e-15  ku0=-3.1999999995790956e-08
+ lku0=2.0000000000000002e-07  wku0=7.000000000000002e-07  pku0=-5.000000000000005e-14
+ voff=-0.12335068648883928  lvoff=6.237881129910642e-10  wvoff=-2.1274321235524548e-08
+ pvoff=2.3033064829442225e-16  eta0=0.35678472933069194  leta0=3.3319215795468794e-09
+ weta0=-2.6349016808547957e-08  peta0=-1.0627831839769227e-14  kt1=-0.26833789653125
+ lkt1=-2.7203700922321402e-09  wkt1=1.4243275093593758e-08  pkt1=-2.671247513825923e-16
+ kt2=-0.05314890519720981  lkt2=-1.7923419843080592e-10  wkt2=-9.113761454788015e-10
+ pkt2=7.329080516832727e-17  kvth0we=0.003500017826540179  lkvth0we=-1.430223378772324e-10
+ wkvth0we=-1.2009448472544818e-11  pkvth0we=1.501184277805815e-17  vth0=0.45197457913125
+ lvth0=-2.044048062767863e-09  wvth0=1.0502743794812496e-08  pvth0=-7.367184529205312e-16
+ a0=0.7852273103348214  la0=1.0770624482589276e-08  wa0=4.4337001834822386e-09
+ pa0=1.5271116776258898e-14  keta=-0.09583402693392858  lketa=4.8106294012500024e-09
+ wketa=6.164032658575905e-09  pketa=8.596702029062232e-17  uc1=6.118478855066957e-12
+ luc1=-9.151386872354904e-18  wuc1=2.0726750711970756e-17  puc1=9.185355206519976e-24
+ ub1=-3.8536730618080345e-18  lub1=-5.273525363169674e-26  wub1=3.0989554538325824e-25
+ pub1=9.369729874229925e-32  ua1=2.84612358609375e-09  lua1=2.6013652931696354e-17
+ wua1=-3.4851851082812704e-17  pua1=-5.839217089223655e-23  pclm=0.5844053760580359
+ lpclm=-2.1407500100446433e-08  wpclm=1.2182703318924093e-07  ppclm=1.453378959823663e-14
+ k2=0.03845986997745535  lk2=1.385888750558037e-09  wk2=-1.405902164457591e-09
+ pk2=-5.338435843926344e-16  vsat=61980.91868169641  lvsat=0.0007905591187946492
+ wvsat=0.009984391504013408  pvsat=-8.668264798674159e-10  uc=9.766813842410709e-11
+ luc=1.57283368000893e-17  wuc=3.011789529537949e-17  puc=-8.278137723875457e-24
+ lmin=1.8e-07  lmax=5e-007  wmin=5.3e-007
+ wmax=1.23e-006

    13:  type=n
+ drout=0.5  saref=1e-05  pbsws=0.32
+ llc=0.0  pdiblcb=0.0  xw=0.0
+ cdsc=0.0  clc=1e-07  minv=-0.34
+ pbswgd=0.952  cdscb=0.0  toxe=3.981e-09
+ cjd=1e-10  cjswgs=3.82e-10  binunit=2.0
+ jtsswgs=1.09e-09  cigsd=3.925e-20  wlodku0=1.0
+ tpbsw=0.000894  rsw=90.88  njd=1.0
+ w0=0.0  pdiblc1=0.0  dwb=0.0
+ igbmod=0.0  dmdg=0.0  delta=0.005
+ wlodvth=1.0  etab=-0.308  permod=1.0
+ tnjtsswg=1.08  dlcig=2.5e-09  rshg=8.23
+ xgl=-3.1e-08  acde=0.4  capmod=2.0
+ noia=1.25e+42  tcjswg=0.00088  cgdo=1e-10
+ rbdb=50.0  cigbinv=0.006  jswgs=6.9e-13
+ wlod=5e-07  xrcrg2=1.0  jsd=2.85e-07
+ prt=0.0  minr=0.001  dmci=3.15e-07
+ ww=0.0  cigbacc=0.2809  wlc=0.0
+ dwj=0.0  dvt1w=0.0  mjswgd=0.541
+ aigbacc=0.01213  beta0=17.8  a1=0.0
+ alpha0=1.454e-07  dvt0=0.09708  lln=1.0
+ aigc=0.01  trnqsmod=0.0  cjs=1e-10
+ lodeta0=2.0  cf=1.0  ijthsfwd=0.01
+ ckappad=0.6  rbsb=50.0  xtsswgd=0.2886
+ ud=0.0  epsrox=3.9  rbpd=50.0
+ tempmod=0.0  alpha1=2.295  pbd=0.6882682
+ xtid=3.0  acnqsmod=0.0  nigbacc=4.05
+ rgatemod=0.0  cgbo=0.0  rsh=7.28
+ jtsswgd=1.09e-09  ngate=9e+19  tcjsw=0.000809
+ poxedge=1.0  xtsswgs=0.2886  mjswd=0.202
+ xrcrg1=12.0  pditsl=0.0  noff=1.973
+ lpeb=2.178e-08  ckappas=0.6  noib=7e+23
+ dmcgt=0.0  dsub=0.633  ll=0.0
+ cgso=1e-10  vtsswgs=10.0  jss=2.85e-07
+ ntox=1.0  dvtp1=0.0  mobmod=0.0
+ njs=1.0  cigc=1.515e-05  cjswd=1.185e-10
+ voffcv=-0.0904  mjsws=0.202  nigbinv=1.0
+ xl=-1.5e-08  ef=0.904  wl=0.0
+ rbodymod=0.0  lwc=0.0  wr=1.0
+ jswd=6.9e-13  pbs=0.6882682  dvt2w=0.0
+ wln=1.0  cdscd=0.0  ijthdrev=0.01
+ dvt0w=0.0  jsws=6.9e-13  nigc=1.0
+ b1=0.0  lint=2.595e-08  rbpb=50.0
+ noic=60800000.0  egidl=0.2624  wwc=0.0
+ dlc=2.595e-08  pbswgs=0.952  vtsswgd=10.0
+ fprout=0.0  lwn=1.0  lwl=0.0
+ ku0we=0.0  rgeomod=1.0  rbps=50.0
+ stk2=2.5e-09  k3=-3.7  dwg=0.0
+ bigc=0.00144  llodku0=1.0  bigbinv=0.03
+ tku0=0.03  xtis=3.0  steta0=-1.1e-10
+ wec=0.0  pscbe2=1e-20  pigcd=2.171
+ dvt1=0.3053  em=30000000.0  ijthdfwd=0.01
+ lodk2=1.0  xj=1.6e-07  ijthsrev=0.01
+ cle=0.6  aigbinv=0.35  njtsswg=11.6
+ tnom=25.0  ndep=5.8e+17  mjs=0.359
+ cgidl=0.25  eigbinv=1.1  xjbvd=1.0
+ phin=0.0  prwg=0.0  nsd=1e+20
+ toxref=3e-09  wwlc=0.0  mjswgs=0.541
+ lw=0.0  bigbacc=0.006537  agidl=2.593e-09
+ wpemod=1.0  dwc=0.0  cgdl=1e-10
+ tpbswg=0.00133  wint=1.02e-08  jswgd=6.9e-13
+ xgw=0.0  a2=0.995  dvtp0=1.46e-06
+ lpe0=9.921e-09  kt1l=0.0  k1=0.448
+ gbmin=1e-12  dmcg=2.05e-07  paramchk=1.0
+ kvsat=0.4  tpb=0.00149  voffl=-1.22e-09
+ xpart=1.0  pbswd=0.32  pscbe1=450000000.0
+ wwl=0.0  cjswgd=3.82e-10  ngcon=1.0
+ mjd=0.359  dvt2=-0.6939  llodvth=1.0
+ pvag=0.6279  k2we=0.0038  diomod=1.0
+ sbref=1e-05  rdsw=200.0  tcj=0.000905
+ rdsmod=1.0  aigsd=0.008379  bvs=11.25
+ dtox=5.958e-10  bgidl=1850800000.0  prwb=0.0
+ wwn=1.0  cgsl=1e-10  moin=5.346
+ bvd=11.25  version=4.5  pditsd=0.0
+ scref=1e-06  bigsd=0.0002699  rdw=90.88
+ igcmod=0.0  b0=0.0  lwlc=0.0
+ fnoimod=1.0  toxm=3.981e-09  pdits=0.0
+ web=0.0  xjbvs=1.0  k3b=1.2
+ cjsws=1.185e-10  at=162978.21615806458  lat=0.0008011703870961475
+ wat=-0.00792711705477421  pat=-6.835548516110398e-11  ua=-7.008284918064518e-10
+ lua=-2.280831612901715e-18  wua=1.6473033377419375e-17  pua=5.98307354838286e-25
+ ub=1.0220558080887093e-18  lub=1.7159629032554325e-28  wub=2.63827920680484e-25
+ pub=8.13019616128619e-34  kvth0=2.1999992865512605e-09  lkvth0=-9.999999999996741e-09
+ wkvth0=2.2e-06  pkvth0=-4.9999999999997016e-14  pdiblc2=0.000601024214830645
+ lpdiblc2=-6.375238548385987e-12  wpdiblc2=1.5748461362725814e-10  ppdiblc2=-1.883773193552825e-19
+ nfactor=1.6473351544193549  lnfactor=4.082524516127039e-09  wnfactor=-6.525590590225808e-08
+ pnfactor=-2.622367935478525e-16  width=7.5e-07  lwidth=-0.0
+ wwidth=-1.1660000000000003e-13  pwidth=-0.0  cit=0.0009080155279112902
+ lcit=2.6235224193573247e-12  wcit=-1.886992530048382e-11  pcit=-1.1725173225878123e-19
+ length=3e-05  llength=-2.0000000000000003e-10  wlength=8.351742236857632e-28
+ plength=-8.351742236857631e-33  u0=0.02609012985729838  lu0=1.3005959677538674e-12
+ wu0=2.0928476184443574e-09  pu0=1.1341278870842477e-18  tvoff=0.001686690707629032
+ ltvoff=2.299105483875852e-12  wtvoff=-9.703113016838702e-11  ptvoff=-1.1247340645321667e-19
+ ags=0.3029355916370969  lags=-3.793106935485664e-09  wags=6.477607584983871e-08
+ pags=2.521873258066363e-16  ute=-1.4448405319032256  lute=-1.582490967743852e-09
+ wute=-2.2831910581290363e-08  pute=-3.070999870963387e-16  ku0=-3.200000034979654e-08
+ lku0=1.9999999999999978e-07  wku0=7.000000000000002e-07  pku0=-5.0000000000000355e-14
+ voff=-0.14664288739193554  lvoff=7.359235483885769e-11  wvoff=-9.94680692774186e-10
+ pvoff=-1.0305538064550323e-17  eta0=0.18436298882903224  leta0=4.3082664516141783e-10
+ weta0=1.0963340121612907e-08  peta0=-8.554714193543884e-17  kt1=-0.2340127944790323
+ lkt1=2.7323796774247184e-10  wkt1=5.199487437387099e-09  pkt1=-1.1493392903230794e-17
+ kt2=-0.05503372752830644  lkt2=-5.440724193735372e-12  wkt2=-3.0645809725853467e-12
+ pkt2=1.1861033226256085e-18  kvth0we=0.0034927746900806442  lkvth0we=1.0255854838754118e-12
+ wkvth0we=-1.1242094407741702e-11  pkvth0we=-1.0753700645322446e-19  vth0=0.45296455916483874
+ lvth0=-4.5980070967952976e-11  wvth0=1.52660544183547e-09  pvth0=2.6000453613118257e-17
+ a0=0.9749327234354838  la0=5.540634516129898e-09  wa0=5.316161254193609e-09
+ pa0=-1.3744457935490212e-15  keta=-0.06062197086744355  lketa=3.2263811290812187e-12
+ wketa=7.271823353067582e-09  pketa=7.677575155159278e-17  uc1=-2.992825644999998e-11
+ luc1=-2.7608712903240864e-19  wuc1=-1.0318997223000005e-17  puc1=-8.54755916128494e-26
+ ub1=-4.228713254782258e-18  lub1=-2.9575172580774477e-27  wub1=2.462824383820967e-25
+ pub1=1.5260871967767952e-33  ua1=2.859722095443547e-09  lua1=-1.5997338708003354e-19
+ wua1=-2.632847434775805e-16  pua1=-1.8474762548412333e-24  pclm=0.6903025322153223
+ lpclm=2.2837827419465846e-10  wpclm=-1.3766817574370925e-08  ppclm=-1.1864148032304906e-16
+ k2=0.04950314149096774  lk2=1.5858890322525698e-11  wk2=-4.2664336403129044e-09
+ pk2=1.7828901290516435e-18  vsat=99832.53201935483  lvsat=0.00019791767741959067
+ wvsat=-0.006070838767258059  pvsat=-4.0579429032346766e-11  uc=6.921116998306451e-11
+ luc=-4.030819193548945e-19  wuc=5.909455994725809e-18  puc=6.967540225805123e-26
+ lmin=1e-005  lmax=2e-05  wmin=2.2e-07
+ wmax=5.3e-007

    14:  type=n
+ drout=0.5  saref=1e-05  pbsws=0.32
+ llc=0.0  pdiblcb=0.0  xw=0.0
+ cdsc=0.0  clc=1e-07  minv=-0.34
+ pbswgd=0.952  cdscb=0.0  toxe=3.981e-09
+ cjd=1e-10  cjswgs=3.82e-10  binunit=2.0
+ jtsswgs=1.09e-09  cigsd=3.925e-20  wlodku0=1.0
+ tpbsw=0.000894  rsw=90.88  njd=1.0
+ w0=0.0  pdiblc1=0.0  dwb=0.0
+ igbmod=0.0  dmdg=0.0  delta=0.005
+ wlodvth=1.0  etab=-0.308  permod=1.0
+ tnjtsswg=1.08  dlcig=2.5e-09  rshg=8.23
+ xgl=-3.1e-08  acde=0.4  capmod=2.0
+ noia=1.25e+42  tcjswg=0.00088  cgdo=1e-10
+ rbdb=50.0  cigbinv=0.006  jswgs=6.9e-13
+ wlod=5e-07  xrcrg2=1.0  jsd=2.85e-07
+ prt=0.0  minr=0.001  dmci=3.15e-07
+ ww=0.0  cigbacc=0.2809  wlc=0.0
+ dwj=0.0  dvt1w=0.0  mjswgd=0.541
+ aigbacc=0.01213  beta0=17.8  a1=0.0
+ alpha0=1.454e-07  dvt0=0.09708  lln=1.0
+ aigc=0.01  trnqsmod=0.0  cjs=1e-10
+ lodeta0=2.0  cf=1.0  ijthsfwd=0.01
+ ckappad=0.6  rbsb=50.0  xtsswgd=0.2886
+ ud=0.0  epsrox=3.9  rbpd=50.0
+ tempmod=0.0  alpha1=2.295  pbd=0.6882682
+ xtid=3.0  acnqsmod=0.0  nigbacc=4.05
+ rgatemod=0.0  cgbo=0.0  rsh=7.28
+ jtsswgd=1.09e-09  ngate=9e+19  tcjsw=0.000809
+ poxedge=1.0  xtsswgs=0.2886  mjswd=0.202
+ xrcrg1=12.0  pditsl=0.0  noff=1.973
+ lpeb=2.178e-08  ckappas=0.6  noib=7e+23
+ dmcgt=0.0  dsub=0.633  ll=0.0
+ cgso=1e-10  vtsswgs=10.0  jss=2.85e-07
+ ntox=1.0  dvtp1=0.0  mobmod=0.0
+ njs=1.0  cigc=1.515e-05  cjswd=1.185e-10
+ voffcv=-0.0904  mjsws=0.202  nigbinv=1.0
+ xl=-1.5e-08  ef=0.904  wl=0.0
+ rbodymod=0.0  lwc=0.0  wr=1.0
+ jswd=6.9e-13  pbs=0.6882682  dvt2w=0.0
+ wln=1.0  cdscd=0.0  ijthdrev=0.01
+ dvt0w=0.0  jsws=6.9e-13  nigc=1.0
+ b1=0.0  lint=2.595e-08  rbpb=50.0
+ noic=60800000.0  egidl=0.2624  wwc=0.0
+ dlc=2.595e-08  pbswgs=0.952  vtsswgd=10.0
+ fprout=0.0  lwn=1.0  lwl=0.0
+ ku0we=0.0  rgeomod=1.0  rbps=50.0
+ stk2=2.5e-09  k3=-3.7  dwg=0.0
+ bigc=0.00144  llodku0=1.0  bigbinv=0.03
+ tku0=0.03  xtis=3.0  steta0=-1.1e-10
+ wec=0.0  pscbe2=1e-20  pigcd=2.171
+ dvt1=0.3053  em=30000000.0  ijthdfwd=0.01
+ lodk2=1.0  xj=1.6e-07  ijthsrev=0.01
+ cle=0.6  aigbinv=0.35  njtsswg=11.6
+ tnom=25.0  ndep=5.8e+17  mjs=0.359
+ cgidl=0.25  eigbinv=1.1  xjbvd=1.0
+ phin=0.0  prwg=0.0  nsd=1e+20
+ toxref=3e-09  wwlc=0.0  mjswgs=0.541
+ lw=0.0  bigbacc=0.006537  agidl=2.593e-09
+ wpemod=1.0  dwc=0.0  cgdl=1e-10
+ tpbswg=0.00133  wint=1.02e-08  jswgd=6.9e-13
+ xgw=0.0  a2=0.995  dvtp0=1.46e-06
+ lpe0=9.921e-09  kt1l=0.0  k1=0.448
+ gbmin=1e-12  dmcg=2.05e-07  paramchk=1.0
+ kvsat=0.4  tpb=0.00149  voffl=-1.22e-09
+ xpart=1.0  pbswd=0.32  pscbe1=450000000.0
+ wwl=0.0  cjswgd=3.82e-10  ngcon=1.0
+ mjd=0.359  dvt2=-0.6939  llodvth=1.0
+ pvag=0.6279  k2we=0.0038  diomod=1.0
+ sbref=1e-05  rdsw=200.0  tcj=0.000905
+ rdsmod=1.0  aigsd=0.008379  bvs=11.25
+ dtox=5.958e-10  bgidl=1850800000.0  prwb=0.0
+ wwn=1.0  cgsl=1e-10  moin=5.346
+ bvd=11.25  version=4.5  pditsd=0.0
+ scref=1e-06  bigsd=0.0002699  rdw=90.88
+ igcmod=0.0  b0=0.0  lwlc=0.0
+ fnoimod=1.0  toxm=3.981e-09  pdits=0.0
+ web=0.0  xjbvs=1.0  k3b=1.2
+ cjsws=1.185e-10  at=175182.18285428884  lat=-0.12123849657514664
+ wat=-0.008975170252943546  pat=1.041217649653226e-08  ua=-7.360448131882331e-10
+ lua=3.49882382204912e-16  wua=2.5517525345729448e-17  pua=-8.98466123282624e-23
+ ub=1.0271278862518328e-18  lub=-5.054918534090874e-26  wub=2.7618251545868778e-25
+ pub=-1.227329281659092e-31  kvth0=2.199998931524812e-09  lkvth0=-1.0000000000001181e-08
+ wkvth0=2.2000000000000005e-06  pkvth0=-4.999999999999958e-14  pdiblc2=0.0005017785608962612
+ lpdiblc2=9.86081300795454e-10  wpdiblc2=1.5505848163691349e-10  ppdiblc2=2.4072942584090966e-17
+ nfactor=1.7098325114626098  lnfactor=-6.20891045916422e-07  wnfactor=-6.914966728313779e-08
+ pnfactor=3.8675377015249166e-14  width=7.5e-07  lwidth=0.0
+ wwidth=-1.1660000000000003e-13  pwidth=0.0  cit=0.000948996999817632
+ lcit=-4.0719119664406145e-10  wcit=-2.1045603482606323e-11  pcit=2.1639530088966242e-17
+ length=1.1200000000000001e-05  llength=-1.2e-11  wlength=0.0
+ plength=0.0  u0=0.02612605439222873  lu0=-3.579447533357575e-10
+ wu0=2.1070867330278613e-09  pu0=-1.4125701794795387e-16  tvoff=0.0017238865091862173
+ ltvoff=-3.696589100879768e-10  wtvoff=-9.910403235505873e-11  ptvoff=2.0616548460264025e-17
+ ags=0.2459427294583944  lags=5.661355148515396e-07  wags=6.84226294327896e-08
+ pags=-3.621334850370234e-14  ute=-1.4688092540377566  lute=2.3810473037756607e-07
+ wute=-2.7752167282148094e-08  pute=4.8895467021480954e-14  ku0=-3.200000038950121e-08
+ lku0=2.0000000000000018e-07  wku0=7.000000000000002e-07  pku0=-5.000000000000004e-14
+ voff=-0.14553335461088712  lvoff=-1.1021735455645094e-08  wvoff=-1.148696798900288e-09
+ pvoff=1.529855523196469e-15  eta0=0.1914355330875733  leta0=-7.029461594024933e-08
+ weta0=9.55429669646115e-09  peta0=1.4004887109582117e-14  kt1=-0.22975220410740468
+ lkt1=-4.2332665748533685e-08  wkt1=5.005991816129037e-09  pkt1=1.923462819677401e-15
+ kt2=-0.055119457326429616  lkt2=8.51857257038133e-10  wkt2=1.572942397360689e-11
+ pkt2=-1.8675394613929676e-16  kvth0we=0.0035081249828170817  lkvth0we=-1.5247734188049805e-10
+ wkvth0we=-1.2852260015212537e-11  pkvth0we=1.5994119068255122e-17  vth0=0.45229040955131966
+ lvth0=6.695516064222816e-09  wvth0=1.9210100305278666e-09  pvth0=-3.918045433310846e-15
+ a0=1.06197791581195  la0=-8.649112892485336e-07  wa0=-1.637257147181085e-08
+ pa0=2.1551288146649557e-13  keta=-0.06063498504893695  lketa=1.333681960630306e-10
+ wketa=8.477404515766127e-09  pketa=-1.1979035875433862e-14  uc1=-3.404623312170088e-11
+ luc1=4.090367958797653e-17  wuc1=-1.1629769125498533e-17  puc1=1.3022243433372434e-23
+ ub1=-4.273443935722142e-18  lub1=4.44349292140764e-25  wub1=2.703952432111439e-25
+ pub1=-2.3960196109369523e-31  ua1=2.858108661400294e-09  lua1=1.5974367045453317e-17
+ wua1=-2.9252553232624644e-16  pua1=2.9056041223181846e-22  pclm=0.6945143956451612
+ lpclm=-4.189025602419333e-08  wpclm=-1.57346662351173e-08  ppclm=1.9559845127140703e-14
+ k2=0.049746940920518685  lk2=-2.4221354051869285e-09  wk2=-4.241951748389112e-09
+ pk2=-2.43036029108876e-16  vsat=102885.32715541606  lvsat=-0.03033003368319284
+ wvsat=-0.006689101638271081  pvsat=6.142049281097881e-09  uc=6.32489328407258e-11
+ luc=5.92192895040323e-17  wuc=6.9064794368585056e-18  puc=-9.900559019068918e-24
+ lmin=1.2e-006  lmax=1e-005  wmin=2.2e-07
+ wmax=5.3e-007

    15:  type=n
+ drout=0.5  saref=1e-05  pbsws=0.32
+ llc=0.0  pdiblcb=0.0  xw=0.0
+ cdsc=0.0  clc=1e-07  minv=-0.34
+ pbswgd=0.952  cdscb=0.0  toxe=3.981e-09
+ cjd=1e-10  cjswgs=3.82e-10  binunit=2.0
+ jtsswgs=1.09e-09  cigsd=3.925e-20  wlodku0=1.0
+ tpbsw=0.000894  rsw=90.88  njd=1.0
+ w0=0.0  pdiblc1=0.0  dwb=0.0
+ igbmod=0.0  dmdg=0.0  delta=0.005
+ wlodvth=1.0  permod=1.0  tnjtsswg=1.08
+ dlcig=2.5e-09  rshg=8.23  xgl=-3.1e-08
+ acde=0.4  capmod=2.0  noia=1.25e+42
+ tcjswg=0.00088  cgdo=1e-10  rbdb=50.0
+ cigbinv=0.006  jswgs=6.9e-13  wlod=5e-07
+ xrcrg2=1.0  jsd=2.85e-07  prt=0.0
+ minr=0.001  dmci=3.15e-07  ww=0.0
+ cigbacc=0.2809  wlc=0.0  dwj=0.0
+ dvt1w=0.0  mjswgd=0.541  aigbacc=0.01213
+ beta0=17.8  a1=0.0  alpha0=1.454e-07
+ dvt0=0.09708  lln=1.0  aigc=0.01
+ trnqsmod=0.0  cjs=1e-10  lodeta0=2.0
+ cf=1.0  ijthsfwd=0.01  ckappad=0.6
+ rbsb=50.0  xtsswgd=0.2886  ud=0.0
+ epsrox=3.9  rbpd=50.0  tempmod=0.0
+ alpha1=2.295  pbd=0.6882682  xtid=3.0
+ acnqsmod=0.0  nigbacc=4.05  rgatemod=0.0
+ cgbo=0.0  rsh=7.28  jtsswgd=1.09e-09
+ ngate=9e+19  tcjsw=0.000809  poxedge=1.0
+ xtsswgs=0.2886  mjswd=0.202  xrcrg1=12.0
+ pditsl=0.0  noff=1.973  lpeb=2.178e-08
+ ckappas=0.6  noib=7e+23  dmcgt=0.0
+ dsub=0.633  ll=0.0  cgso=1e-10
+ vtsswgs=10.0  jss=2.85e-07  ntox=1.0
+ dvtp1=0.0  mobmod=0.0  njs=1.0
+ cigc=1.515e-05  cjswd=1.185e-10  voffcv=-0.0904
+ mjsws=0.202  nigbinv=1.0  xl=-1.5e-08
+ ef=0.904  wl=0.0  rbodymod=0.0
+ lwc=0.0  wr=1.0  jswd=6.9e-13
+ pbs=0.6882682  dvt2w=0.0  wln=1.0
+ cdscd=0.0  ijthdrev=0.01  dvt0w=0.0
+ jsws=6.9e-13  nigc=1.0  b1=0.0
+ lint=2.595e-08  rbpb=50.0  noic=60800000.0
+ egidl=0.2624  wwc=0.0  dlc=2.595e-08
+ pbswgs=0.952  vtsswgd=10.0  fprout=0.0
+ lwn=1.0  lwl=0.0  ku0we=0.0
+ rgeomod=1.0  rbps=50.0  stk2=2.5e-09
+ k3=-3.7  dwg=0.0  bigc=0.00144
+ llodku0=1.0  bigbinv=0.03  tku0=0.03
+ xtis=3.0  steta0=-1.1e-10  wec=0.0
+ pscbe2=1e-20  pigcd=2.171  dvt1=0.3053
+ em=30000000.0  ijthdfwd=0.01  lodk2=1.0
+ xj=1.6e-07  ijthsrev=0.01  cle=0.6
+ aigbinv=0.35  njtsswg=11.6  tnom=25.0
+ ndep=5.8e+17  mjs=0.359  cgidl=0.25
+ eigbinv=1.1  xjbvd=1.0  phin=0.0
+ prwg=0.0  nsd=1e+20  toxref=3e-09
+ wwlc=0.0  mjswgs=0.541  lw=0.0
+ bigbacc=0.006537  agidl=2.593e-09  wpemod=1.0
+ dwc=0.0  cgdl=1e-10  tpbswg=0.00133
+ wint=1.02e-08  jswgd=6.9e-13  xgw=0.0
+ a2=0.995  dvtp0=1.46e-06  lpe0=9.921e-09
+ kt1l=0.0  k1=0.448  gbmin=1e-12
+ dmcg=2.05e-07  paramchk=1.0  kvsat=0.4
+ tpb=0.00149  voffl=-1.22e-09  xpart=1.0
+ pbswd=0.32  pscbe1=450000000.0  wwl=0.0
+ cjswgd=3.82e-10  ngcon=1.0  mjd=0.359
+ dvt2=-0.6939  llodvth=1.0  pvag=0.6279
+ k2we=0.0038  diomod=1.0  sbref=1e-05
+ rdsw=200.0  tcj=0.000905  rdsmod=1.0
+ aigsd=0.008379  bvs=11.25  dtox=5.958e-10
+ bgidl=1850800000.0  prwb=0.0  wwn=1.0
+ cgsl=1e-10  moin=5.346  bvd=11.25
+ version=4.5  pditsd=0.0  scref=1e-06
+ bigsd=0.0002699  rdw=90.88  igcmod=0.0
+ b0=0.0  lwlc=0.0  fnoimod=1.0
+ toxm=3.981e-09  pdits=0.0  web=0.0
+ xjbvs=1.0  k3b=1.2  cjsws=1.185e-10
+ at=122232.69789343314  lat=-0.0576991146221198  wat=-0.0024992991829838602
+ pat=2.641131212580639e-09  ua=-4.5417536276497686e-10  lua=1.1639041697004473e-17
+ wua=6.7189782154377416e-18  pua=-6.728835577191237e-23  ub=3.2387380085253503e-19
+ lub=7.933557171382484e-25  wub=2.270080297552994e-25  pub=-6.372354532184316e-32
+ etab=-0.31104479467741936  letab=3.653753612903226e-09  wetab=1.5816275147465517e-09
+ petab=-1.8979530176958614e-15  kvth0=2.199998546956794e-09  lkvth0=-9.99999999999967e-09
+ wkvth0=2.200000000000001e-06  pkvth0=-5.0000000000000235e-14  pdiblc2=0.0015431922580069121
+ lpdiblc2=-2.636151357373269e-10  wpdiblc2=3.418150888133658e-11  ppdiblc2=1.6912530989078322e-16
+ nfactor=1.3525362558986178  lnfactor=-1.9213553923963162e-07  wnfactor=-8.15168862548388e-08
+ pnfactor=5.351603978129037e-14  width=7.5e-07  lwidth=0.0
+ wwidth=-1.1660000000000003e-13  pwidth=0.0  cit=0.0004851203618595537
+ lcit=1.4946076890563254e-10  wcit=9.749801348098545e-11  pcit=-1.2061281026734384e-16
+ length=1.7e-06  llength=-6.000000000000001e-13  wlength=0.0
+ plength=0.0  u0=0.02144615115622121  lu0=5.257939129873269e-09
+ wu0=2.909132722774189e-09  pu0=-1.1037122056435466e-15  tvoff=0.0009513718594124425
+ ltvoff=5.573586696405528e-10  wtvoff=1.2117541886405508e-11  ptvoff=-1.1284934062949303e-16
+ ags=0.26170075519585256  lags=5.472258839665897e-07  wags=1.0825666208548384e-07
+ pags=-8.40141876869354e-14  ute=-1.4061521869112903  lute=1.629162498258064e-07
+ wute=6.247223523476963e-08  pute=-5.937381599882027e-14  ku0=-3.200000032423131e-08
+ lku0=2.0000000000000026e-07  wku0=7.000000000000001e-07  pku0=-5.000000000000002e-14
+ voff=-0.14689617502937785  lvoff=-9.386350953456233e-09  wvoff=-1.409541192108305e-09
+ pvoff=1.8428687950460893e-15  eta0=0.013783906176728006  leta0=1.4288733635276503e-07
+ weta0=4.62021929762627e-08  peta0=-2.997258842617973e-14  kt1=-0.2768637888006912
+ lkt1=1.4201235883410092e-08  wkt1=1.1121757027580624e-08  pkt1=-5.4154554340645016e-15
+ kt2=-0.05396910016474653  lkt2=-5.285713369815749e-10  wkt2=-2.6854531375576313e-10
+ pkt2=1.5437573913594713e-16  kvth0we=0.0035003894968894007  lkvth0we=-1.4319475876728092e-10
+ wkvth0we=-1.2040859887096655e-11  pkvth0we=1.5020438914516066e-17  vth0=0.4471821350046082
+ lvth0=1.2825445520276561e-08  wvth0=6.904958061290533e-10  pvth0=-2.4414283640322706e-15
+ a0=-0.052910569205069445  la0=4.7295489277188945e-07  wa0=2.874699327822581e-07
+ pa0=-1.4909812363838702e-13  keta=-0.04235289254458527  lketa=-2.1805142809158966e-08
+ wketa=-7.011417806334094e-09  pketa=6.607550911086398e-15  uc1=-4.0101606217741944e-11
+ luc1=4.817012730322581e-17  wuc1=-3.3573287299539116e-18  puc1=3.0953149587188894e-24
+ ub1=-4.1590666014055285e-18  lub1=3.070964909608291e-25  wub1=-7.713029147649784e-26
+ pub1=1.7742868053147465e-31  ua1=2.6193654432718883e-09  lua1=3.0246622879953933e-16
+ wua1=1.4539546748018464e-16  pua1=-2.3494478753589864e-22  pclm=0.4723214370391706
+ lpclm=2.2474129430299522e-07  wpclm=3.712508092281096e-08  ppclm=-4.387185146237318e-14
+ k2=0.048110731010253475  lk2=-4.5868351286867646e-10  wk2=-3.5953265521129084e-09
+ pk2=-1.01898626464032e-15  vsat=78719.77622200457  lvsat=-0.0013313725630990597
+ wvsat=-0.0038558121431267185  pvsat=2.7421018869246478e-09  uc=3.9818034561059956e-11
+ luc=8.733636743963129e-17  wuc=2.0326264423709665e-17  puc=-2.6004301003290303e-23
+ lmin=5e-007  lmax=1.2e-006  wmin=2.2e-07
+ wmax=5.3e-007

    16:  type=n
+ drout=0.5  saref=1e-05  pbsws=0.32
+ llc=0.0  pdiblcb=0.0  xw=0.0
+ cdsc=0.0  clc=1e-07  minv=-0.34
+ pbswgd=0.952  cdscb=0.0  toxe=3.981e-09
+ cjd=1e-10  cjswgs=3.82e-10  binunit=2.0
+ jtsswgs=1.09e-09  cigsd=3.925e-20  wlodku0=1.0
+ tpbsw=0.000894  rsw=90.88  njd=1.0
+ w0=0.0  pdiblc1=0.0  dwb=0.0
+ igbmod=0.0  dmdg=0.0  delta=0.005
+ wlodvth=1.0  permod=1.0  tnjtsswg=1.08
+ dlcig=2.5e-09  rshg=8.23  xgl=-3.1e-08
+ acde=0.4  capmod=2.0  noia=1.25e+42
+ tcjswg=0.00088  cgdo=1e-10  rbdb=50.0
+ cigbinv=0.006  jswgs=6.9e-13  wlod=5e-07
+ xrcrg2=1.0  jsd=2.85e-07  prt=0.0
+ minr=0.001  dmci=3.15e-07  ww=0.0
+ cigbacc=0.2809  wlc=0.0  dwj=0.0
+ dvt1w=0.0  mjswgd=0.541  aigbacc=0.01213
+ beta0=17.8  a1=0.0  alpha0=1.454e-07
+ dvt0=0.09708  lln=1.0  aigc=0.01
+ trnqsmod=0.0  cjs=1e-10  lodeta0=2.0
+ cf=1.0  ijthsfwd=0.01  ckappad=0.6
+ rbsb=50.0  xtsswgd=0.2886  ud=0.0
+ epsrox=3.9  rbpd=50.0  tempmod=0.0
+ alpha1=2.295  pbd=0.6882682  xtid=3.0
+ acnqsmod=0.0  nigbacc=4.05  rgatemod=0.0
+ cgbo=0.0  rsh=7.28  jtsswgd=1.09e-09
+ ngate=9e+19  tcjsw=0.000809  poxedge=1.0
+ xtsswgs=0.2886  mjswd=0.202  xrcrg1=12.0
+ pditsl=0.0  noff=1.973  lpeb=2.178e-08
+ ckappas=0.6  noib=7e+23  dmcgt=0.0
+ dsub=0.633  ll=0.0  cgso=1e-10
+ vtsswgs=10.0  jss=2.85e-07  ntox=1.0
+ dvtp1=0.0  mobmod=0.0  njs=1.0
+ cigc=1.515e-05  cjswd=1.185e-10  voffcv=-0.0904
+ mjsws=0.202  nigbinv=1.0  xl=-1.5e-08
+ ef=0.904  wl=0.0  rbodymod=0.0
+ lwc=0.0  wr=1.0  jswd=6.9e-13
+ pbs=0.6882682  dvt2w=0.0  wln=1.0
+ cdscd=0.0  ijthdrev=0.01  dvt0w=0.0
+ jsws=6.9e-13  nigc=1.0  b1=0.0
+ lint=2.595e-08  rbpb=50.0  noic=60800000.0
+ egidl=0.2624  wwc=0.0  dlc=2.595e-08
+ pbswgs=0.952  vtsswgd=10.0  fprout=0.0
+ lwn=1.0  lwl=0.0  ku0we=0.0
+ rgeomod=1.0  rbps=50.0  stk2=2.5e-09
+ k3=-3.7  dwg=0.0  bigc=0.00144
+ llodku0=1.0  bigbinv=0.03  tku0=0.03
+ xtis=3.0  steta0=-1.1e-10  wec=0.0
+ pscbe2=1e-20  pigcd=2.171  dvt1=0.3053
+ em=30000000.0  ijthdfwd=0.01  lodk2=1.0
+ xj=1.6e-07  ijthsrev=0.01  cle=0.6
+ aigbinv=0.35  njtsswg=11.6  tnom=25.0
+ ndep=5.8e+17  mjs=0.359  cgidl=0.25
+ eigbinv=1.1  xjbvd=1.0  phin=0.0
+ prwg=0.0  nsd=1e+20  toxref=3e-09
+ wwlc=0.0  mjswgs=0.541  lw=0.0
+ bigbacc=0.006537  agidl=2.593e-09  wpemod=1.0
+ dwc=0.0  cgdl=1e-10  tpbswg=0.00133
+ wint=1.02e-08  jswgd=6.9e-13  xgw=0.0
+ a2=0.995  dvtp0=1.46e-06  lpe0=9.921e-09
+ kt1l=0.0  k1=0.448  gbmin=1e-12
+ dmcg=2.05e-07  paramchk=1.0  kvsat=0.4
+ tpb=0.00149  voffl=-1.22e-09  xpart=1.0
+ pbswd=0.32  pscbe1=450000000.0  wwl=0.0
+ cjswgd=3.82e-10  ngcon=1.0  mjd=0.359
+ dvt2=-0.6939  llodvth=1.0  pvag=0.6279
+ k2we=0.0038  diomod=1.0  sbref=1e-05
+ rdsw=200.0  tcj=0.000905  rdsmod=1.0
+ aigsd=0.008379  bvs=11.25  dtox=5.958e-10
+ bgidl=1850800000.0  prwb=0.0  wwn=1.0
+ cgsl=1e-10  moin=5.346  bvd=11.25
+ version=4.5  pditsd=0.0  scref=1e-06
+ bigsd=0.0002699  rdw=90.88  igcmod=0.0
+ b0=0.0  lwlc=0.0  fnoimod=1.0
+ toxm=3.981e-09  pdits=0.0  web=0.0
+ xjbvs=1.0  k3b=1.2  cjsws=1.185e-10
+ at=7272.424734022173  lat=-0.00021897804241431283  wat=0.0031278778552026212
+ pat=-1.7245730651260109e-10  ua=-3.4874668553931455e-10  lua=-4.107529691582661e-17
+ wua=-1.4582638329072578e-16  pua=8.984324981169352e-24  ub=1.7258761257560474e-18
+ lub=9.235455468649213e-26  wub=1.659448872711697e-25  pub=-3.319197407977832e-32
+ etab=-0.250942804969758  letab=-2.6397241240927446e-08  wetab=-2.9638529556653275e-08
+ petab=1.3712125518004043e-14  kvth0=2.1999978337582954e-09  lkvth0=-9.99999999999953e-09
+ wkvth0=2.200000000000001e-06  pkvth0=-5.000000000000015e-14  pdiblc2=0.0008486729614062494
+ lpdiblc2=8.364451256300414e-11  wpdiblc2=4.910692860343751e-10  ppdiblc2=-5.931857868573593e-17
+ nfactor=0.9181195669354835  lnfactor=2.5072805241935562e-08  wnfactor=5.472768786794369e-08
+ pnfactor=-1.4606247280100833e-14  width=7.5e-07  lwidth=0.0
+ wwidth=-1.1660000000000003e-13  pwidth=0.0  cit=0.0007750621823792651
+ lcit=4.489858645776865e-12  wcit=-1.3500537056387246e-10  pcit=-4.361118244914933e-18
+ length=6.8e-07  llength=-9e-14  wlength=0.0
+ plength=0.0  u0=0.031923602361139114  lu0=1.9213527414315942e-11
+ wu0=6.008080008618932e-10  pu0=5.0450155312600705e-17  tvoff=0.0020552688780493948
+ ltvoff=5.4101603220766535e-12  wtvoff=-2.2304107132711697e-10  ptvoff=4.729965977268144e-18
+ ags=1.5387419406249998  lags=-9.129470874798377e-08  wags=-7.349504599999993e-08
+ pags=6.861666355806433e-15  ute=-1.0379967925478832  lute=-2.116144735589714e-08
+ wute=-7.41362856894657e-08  pute=8.930444463297368e-15  ku0=-3.1999999357944654e-08
+ lku0=1.9999999999999973e-07  wku0=6.999999999999999e-07  pku0=-4.999999999999992e-14
+ voff=-0.17162567491809474  lvoff=2.9783989909022152e-09  wvoff=4.311422631980853e-09
+ pvoff=-1.0176131169984876e-15  eta0=0.3565383473462702  leta0=-2.8489884232006065e-08
+ weta0=-2.621843435680446e-08  peta0=6.237725240353833e-15  kt1=-0.23727356398941532
+ lkt1=-5.593876522227834e-09  wkt1=-2.2208211535786358e-09  pkt1=1.255833656515125e-15
+ kt2=-0.05485402138306452  lkt2=-8.611072782257943e-11  wkt2=-7.664566975803212e-12
+ pkt2=2.393536574596723e-17  kvth0we=0.0034999999474798387  lkvth0we=-1.4299998406249997e-10
+ wkvth0we=-1.1999972570564443e-11  pkvth0we=1.499999525624996e-17  vth0=0.46614268795362906
+ lvth0=3.3451690457661323e-09  wvth0=2.993646118951611e-09  pvth0=-3.593003520443549e-15
+ a0=0.7530044586441534  la0=6.999737884727815e-08  wa0=2.151181157953631e-08
+ pa0=-1.61190630370262e-14  keta=-0.09900669265372983  lketa=6.521757245413303e-09
+ wketa=7.845545490070564e-09  pketa=-8.209307371159275e-16  uc1=4.3796138570060476e-11
+ luc1=6.221254909324599e-18  wuc1=7.575910630241916e-19  puc1=1.0378550622298388e-24
+ ub1=-3.744798465826613e-18  lub1=9.996242317137087e-26  wub1=2.521920095131048e-25
+ pub1=1.2767530036673418e-32  ua1=3.473854297530242e-09  lua1=-1.2477819832963708e-16
+ wua1=-3.6754912814415333e-16  pua1=2.1527510276270178e-23  pclm=0.8795218235483867
+ lpclm=2.1141101048387164e-08  wpclm=-3.4584683980645086e-08  ppclm=-8.016969010645178e-15
+ k2=0.046203105340221776  lk2=4.951293221471785e-10  wk2=-5.509816906723791e-09
+ pk2=-6.17410873348792e-17  vsat=80617.73937701616  lvsat=-0.0022803541406048434
+ wvsat=0.00010687653549394877  pvsat=7.607575476143152e-10  uc=2.0256382310735885e-10
+ luc=5.963473166481851e-18  wuc=-2.5476817586743943e-17  puc=-3.1027599980635093e-24
+ lmin=1.8e-07  lmax=5e-007  wmin=2.2e-07
+ wmax=5.3e-007
}
